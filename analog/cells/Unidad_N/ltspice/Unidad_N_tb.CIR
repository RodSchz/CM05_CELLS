* C:\Users\esmer\CIDESI\CM05_CELLS\analog\cells\Unidad_N\ltspice\Unidad_N_tb.asc
* Generated by LTspice 26.0.2 for Windows.
XX1 D G 0 Unidad_N

* block symbol definitions
.subckt Unidad_N D G COM
M1 COM COM COM COM CIDNMOS l=10u w=100u
M2 D G COM COM CIDNMOS l=10u w=100u
M3 COM COM COM COM CIDNMOS l=10u w=100u
.ends Unidad_N

.model NMOS NMOS
.model PMOS PMOS
.lib C:\Users\esmer\AppData\Local\LTspice\lib\cmp\standard.mos
.backanno
.end
