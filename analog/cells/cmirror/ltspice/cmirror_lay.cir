* Extracted by KLayout (CIDESI_CM05, LNunT, CIDESI)

.SUBCKT cmirror_lay P1 P2 COM
M$1 P2 P1 COM COM CIDNMOS L=10U W=100U AS=2000P AD=2000P PS=240U PD=240U
M$2 COM P1 P1 COM CIDNMOS L=8U W=100U AS=2100P AD=2100P PS=242U PD=242U
.ENDS cmirror_lay
