* C:\Users\esmer\CIDESI\CM05_CELLS\analog\cells\Unidad_P\ltspice\Unidad_P_tb.asc
* Generated by LTspice 26.0.2 for Windows.
XX1 D G 0 Unidad_P

* block symbol definitions
.subckt Unidad_P D G COM
M1 COM COM COM COM CIDPMOS l=10u w=100u
M2 D G COM COM CIDPMOS l=10u w=100u
M3 COM COM COM COM CIDPMOS l=10u w=100u
.ends Unidad_P

.model NMOS NMOS
.model PMOS PMOS
.lib C:\Users\esmer\AppData\Local\LTspice\lib\cmp\standard.mos
.backanno
.end
