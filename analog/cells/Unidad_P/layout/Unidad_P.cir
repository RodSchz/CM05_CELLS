* Extracted by KLayout (CIDESI_CM05, LNunT, CIDESI)

.SUBCKT Unidad_P G D COM
M$1 COM COM COM COM CIDPMOS L=10U W=100U AS=1500P AD=1500P PS=230U PD=230U
M$2 D G COM COM CIDPMOS L=10U W=100U AS=1500P AD=1500P PS=230U PD=230U
M$3 COM COM COM COM CIDPMOS L=10U W=100U AS=1500P AD=1500P PS=230U PD=230U
.ENDS Unidad_P
