* Extracted by KLayout (CIDESI_CM05, LNunT, CIDESI)

.SUBCKT FFD Q CLK CB C Data QB CLB PRB VDD GND
M$1 VDD \$12 Q VDD CIDPMOS L=5U W=25U AS=312.5P AD=187.5P PS=75U PD=40U
M$2 \$13 \$10 VDD VDD CIDPMOS L=5U W=25U AS=187.5P AD=187.5P PS=40U PD=40U
M$3 VDD PRB \$13 VDD CIDPMOS L=5U W=25U AS=187.5P AD=187.5P PS=40U PD=40U
M$4 QB \$13 VDD VDD CIDPMOS L=5U W=25U AS=187.5P AD=312.5P PS=40U PD=75U
M$5 \$12 C \$10 VDD CIDPMOS L=5U W=25U AS=312.5P AD=187.5P PS=75U PD=40U
M$6 VDD CLB \$12 VDD CIDPMOS L=5U W=25U AS=187.5P AD=187.5P PS=40U PD=40U
M$7 \$12 \$13 VDD VDD CIDPMOS L=5U W=25U AS=187.5P AD=312.5P PS=40U PD=75U
M$8 \$38 CB \$10 VDD CIDPMOS L=5U W=25U AS=312.5P AD=93.75P PS=75U PD=32.5U
M$9 VDD \$9 \$38 VDD CIDPMOS L=5U W=25U AS=93.75P AD=312.5P PS=32.5U PD=75U
M$10 \$31 C \$7 VDD CIDPMOS L=5U W=25U AS=312.5P AD=93.75P PS=75U PD=32.5U
M$11 VDD Data \$31 VDD CIDPMOS L=5U W=25U AS=93.75P AD=312.5P PS=32.5U PD=75U
M$12 \$34 CB \$7 VDD CIDPMOS L=5U W=25U AS=312.5P AD=93.75P PS=75U PD=32.5U
M$13 VDD \$9 \$34 VDD CIDPMOS L=5U W=25U AS=93.75P AD=312.5P PS=32.5U PD=75U
M$14 \$35 CB \$7 VDD CIDPMOS L=5U W=25U AS=312.5P AD=93.75P PS=75U PD=32.5U
M$15 VDD CLB \$35 VDD CIDPMOS L=5U W=25U AS=93.75P AD=187.5P PS=32.5U PD=40U
M$16 \$9 \$7 VDD VDD CIDPMOS L=5U W=25U AS=187.5P AD=187.5P PS=40U PD=40U
M$17 VDD PRB \$9 VDD CIDPMOS L=5U W=25U AS=187.5P AD=312.5P PS=40U PD=75U
M$18 VDD CLK CB VDD CIDPMOS L=5U W=25U AS=312.5P AD=187.5P PS=75U PD=40U
M$19 C CB VDD VDD CIDPMOS L=5U W=25U AS=187.5P AD=312.5P PS=40U PD=75U
M$20 \$17 PRB \$13 GND CIDNMOS L=5U W=10U AS=125P AD=37.5P PS=45U PD=17.5U
M$21 GND \$10 \$17 GND CIDNMOS L=5U W=10U AS=37.5P AD=75P PS=17.5U PD=25U
M$22 QB \$13 GND GND CIDNMOS L=5U W=10U AS=75P AD=125P PS=25U PD=45U
M$23 GND \$12 Q GND CIDNMOS L=5U W=10U AS=125P AD=125P PS=45U PD=45U
M$24 \$25 \$13 GND GND CIDNMOS L=5U W=10U AS=125P AD=37.5P PS=45U PD=17.5U
M$25 \$12 CLB \$25 GND CIDNMOS L=5U W=10U AS=37.5P AD=125P PS=17.5U PD=45U
M$26 GND CLK CB GND CIDNMOS L=5U W=10U AS=125P AD=75P PS=45U PD=25U
M$27 C CB GND GND CIDNMOS L=5U W=10U AS=75P AD=125P PS=25U PD=45U
M$28 \$18 C \$7 GND CIDNMOS L=5U W=10U AS=125P AD=37.5P PS=45U PD=17.5U
M$29 \$19 \$9 \$18 GND CIDNMOS L=5U W=10U AS=37.5P AD=37.5P PS=17.5U PD=17.5U
M$30 GND CLB \$19 GND CIDNMOS L=5U W=10U AS=37.5P AD=75P PS=17.5U PD=25U
M$31 \$20 \$7 GND GND CIDNMOS L=5U W=10U AS=75P AD=37.5P PS=25U PD=17.5U
M$32 \$9 PRB \$20 GND CIDNMOS L=5U W=10U AS=37.5P AD=125P PS=17.5U PD=45U
M$33 \$16 CB \$7 GND CIDNMOS L=5U W=10U AS=125P AD=37.5P PS=45U PD=17.5U
M$34 GND Data \$16 GND CIDNMOS L=5U W=10U AS=37.5P AD=125P PS=17.5U PD=45U
M$35 \$22 \$9 GND GND CIDNMOS L=5U W=10U AS=125P AD=37.5P PS=45U PD=17.5U
M$36 \$23 C \$22 GND CIDNMOS L=5U W=10U AS=37.5P AD=37.5P PS=17.5U PD=17.5U
M$37 \$10 CLB \$23 GND CIDNMOS L=5U W=10U AS=37.5P AD=125P PS=17.5U PD=45U
M$38 \$10 CB \$12 GND CIDNMOS L=5U W=10U AS=125P AD=125P PS=45U PD=45U
.ENDS FFD
