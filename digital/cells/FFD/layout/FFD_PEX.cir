* Extracted by KLayout (CIDESI_CM05, LNunT, CIDESI)

.SUBCKT FFD Q CLK CB C Data QB CLB PRB VDD GND
M$1 VDD \$12 Q VDD CIDPMOS L=5U W=25U AS=312.5P AD=187.5P PS=75U PD=40U
M$2 \$13 \$10 VDD VDD CIDPMOS L=5U W=25U AS=187.5P AD=187.5P PS=40U PD=40U
M$3 VDD PRB \$13 VDD CIDPMOS L=5U W=25U AS=187.5P AD=187.5P PS=40U PD=40U
M$4 QB \$13 VDD VDD CIDPMOS L=5U W=25U AS=187.5P AD=312.5P PS=40U PD=75U
M$5 \$12 C \$10 VDD CIDPMOS L=5U W=25U AS=312.5P AD=187.5P PS=75U PD=40U
M$6 VDD CLB \$12 VDD CIDPMOS L=5U W=25U AS=187.5P AD=187.5P PS=40U PD=40U
M$7 \$12 \$13 VDD VDD CIDPMOS L=5U W=25U AS=187.5P AD=312.5P PS=40U PD=75U
M$8 \$38 CB \$10 VDD CIDPMOS L=5U W=25U AS=312.5P AD=93.75P PS=75U PD=32.5U
M$9 VDD \$9 \$38 VDD CIDPMOS L=5U W=25U AS=93.75P AD=312.5P PS=32.5U PD=75U
M$10 \$31 C \$7 VDD CIDPMOS L=5U W=25U AS=312.5P AD=93.75P PS=75U PD=32.5U
M$11 VDD Data \$31 VDD CIDPMOS L=5U W=25U AS=93.75P AD=312.5P PS=32.5U PD=75U
M$12 \$34 CB \$7 VDD CIDPMOS L=5U W=25U AS=312.5P AD=93.75P PS=75U PD=32.5U
M$13 VDD \$9 \$34 VDD CIDPMOS L=5U W=25U AS=93.75P AD=312.5P PS=32.5U PD=75U
M$14 \$35 CB \$7 VDD CIDPMOS L=5U W=25U AS=312.5P AD=93.75P PS=75U PD=32.5U
M$15 VDD CLB \$35 VDD CIDPMOS L=5U W=25U AS=93.75P AD=187.5P PS=32.5U PD=40U
M$16 \$9 \$7 VDD VDD CIDPMOS L=5U W=25U AS=187.5P AD=187.5P PS=40U PD=40U
M$17 VDD PRB \$9 VDD CIDPMOS L=5U W=25U AS=187.5P AD=312.5P PS=40U PD=75U
M$18 VDD CLK CB VDD CIDPMOS L=5U W=25U AS=312.5P AD=187.5P PS=75U PD=40U
M$19 C CB VDD VDD CIDPMOS L=5U W=25U AS=187.5P AD=312.5P PS=40U PD=75U
M$20 \$17 PRB \$13 GND CIDNMOS L=5U W=10U AS=125P AD=37.5P PS=45U PD=17.5U
M$21 GND \$10 \$17 GND CIDNMOS L=5U W=10U AS=37.5P AD=75P PS=17.5U PD=25U
M$22 QB \$13 GND GND CIDNMOS L=5U W=10U AS=75P AD=125P PS=25U PD=45U
M$23 GND \$12 Q GND CIDNMOS L=5U W=10U AS=125P AD=125P PS=45U PD=45U
M$24 \$25 \$13 GND GND CIDNMOS L=5U W=10U AS=125P AD=37.5P PS=45U PD=17.5U
M$25 \$12 CLB \$25 GND CIDNMOS L=5U W=10U AS=37.5P AD=125P PS=17.5U PD=45U
M$26 GND CLK CB GND CIDNMOS L=5U W=10U AS=125P AD=75P PS=45U PD=25U
M$27 C CB GND GND CIDNMOS L=5U W=10U AS=75P AD=125P PS=25U PD=45U
M$28 \$18 C \$7 GND CIDNMOS L=5U W=10U AS=125P AD=37.5P PS=45U PD=17.5U
M$29 \$19 \$9 \$18 GND CIDNMOS L=5U W=10U AS=37.5P AD=37.5P PS=17.5U PD=17.5U
M$30 GND CLB \$19 GND CIDNMOS L=5U W=10U AS=37.5P AD=75P PS=17.5U PD=25U
M$31 \$20 \$7 GND GND CIDNMOS L=5U W=10U AS=75P AD=37.5P PS=25U PD=17.5U
M$32 \$9 PRB \$20 GND CIDNMOS L=5U W=10U AS=37.5P AD=125P PS=17.5U PD=45U
M$33 \$16 CB \$7 GND CIDNMOS L=5U W=10U AS=125P AD=37.5P PS=45U PD=17.5U
M$34 GND Data \$16 GND CIDNMOS L=5U W=10U AS=37.5P AD=125P PS=17.5U PD=45U
M$35 \$22 \$9 GND GND CIDNMOS L=5U W=10U AS=125P AD=37.5P PS=45U PD=17.5U
M$36 \$23 C \$22 GND CIDNMOS L=5U W=10U AS=37.5P AD=37.5P PS=17.5U PD=17.5U
M$37 \$10 CLB \$23 GND CIDNMOS L=5U W=10U AS=37.5P AD=125P PS=17.5U PD=45U
M$38 \$10 CB \$12 GND CIDNMOS L=5U W=10U AS=125P AD=125P PS=45U PD=45U
C$39 PRB VDD 5.32358042497e-15 ; C_PAR_M1M2
C$40 Q VDD 2.7337304885e-15 ; C_PAR_M1M2
C$41 Data VDD 2.7337304885e-15 ; C_PAR_M1M2
C$42 Data CB 3.10781992377e-14 ; C_PAR_M1M2
C$43 \$10 Q 2.30208883242e-15 ; C_PAR_M1M2
C$44 \$7 \$9 1.72656662432e-15 ; C_PAR_M1M2
C$45 \$10 CLB 5.75522208105e-16 ; C_PAR_M1M2
C$46 CLB \$9 1.72656662432e-15 ; C_PAR_M1M2
C$47 PRB GND 9.06447477765e-15 ; C_PAR_M1M2
C$48 PRB \$13 1.72656662432e-15 ; C_PAR_M1M2
C$49 \$9 CLB 2.30208883242e-15 ; C_PAR_M1M2
C$50 \$10 \$9 2.30208883242e-15 ; C_PAR_M1M2
C$51 \$13 Q 2.30208883242e-15 ; C_PAR_M1M2
C$52 PRB \$13 3.16537214458e-15 ; C_PAR_M1M2
C$53 CLB \$10 2.30208883242e-15 ; C_PAR_M1M2
C$54 CLK VDD 2.7337304885e-15 ; C_PAR_M1M2
C$55 PRB \$9 2.30208883242e-15 ; C_PAR_M1M2
C$56 PRB QB 1.43880552026e-15 ; C_PAR_M1M2
C$57 \$9 CLB 8.63283312158e-16 ; C_PAR_M1M2
C$58 Q GND 2.7337304885e-15 ; C_PAR_M1M2
C$59 \$9 \$10 1.72656662432e-15 ; C_PAR_M1M2
C$60 Data GND 2.7337304885e-15 ; C_PAR_M1M2
C$61 CLK GND 2.7337304885e-15 ; C_PAR_M1M2
C$62 \$13 \$12 2.30208883242e-15 ; C_PAR_M1M2
C$63 PRB \$13 1.72656662432e-15 ; C_PAR_M1M2
C$64 PRB \$12 2.30208883242e-15 ; C_PAR_M1M2
C$65 PRB Q 2.30208883242e-15 ; C_PAR_M1M2
C$66 PRB \$10 2.30208883242e-15 ; C_PAR_M1M2
C$67 PRB \$13 1.72656662432e-15 ; C_PAR_M1M2
C$68 QB VDD 2.87761104052e-15 ; C_PAR_M1M2
C$69 \$10 \$12 2.30208883242e-15 ; C_PAR_M1M2
C$70 \$12 \$10 2.30208883242e-15 ; C_PAR_M1M2
C$71 Data C 1.72656662432e-15 ; C_PAR_M1M2
C$72 Data \$7 2.30208883242e-15 ; C_PAR_M1M2
C$73 PRB \$10 1.72656662432e-15 ; C_PAR_M1M2
C$74 \$9 PRB 5.75522208105e-16 ; C_PAR_M1M2
C$75 \$7 Data 2.44596938445e-15 ; C_PAR_M1M2
C$76 CLB \$10 1.72656662432e-15 ; C_PAR_M1M2
C$77 PRB \$10 2.30208883242e-15 ; C_PAR_M1M2
C$78 QB GND 2.87761104052e-15 ; C_PAR_M1M2
C$79 PRB CLB 4.74805821687e-15 ; C_PAR_M1M2
C$80 \$13 \$10 2.30208883242e-15 ; C_PAR_M1M2
C$81 GND GND 3.0114534145e-15 ; C_M1_SUB
C$82 GND GND 3.0114534145e-15 ; C_M1_SUB
C$83 GND GND 1.00381780483e-15 ; C_M1_SUB
C$84 GND GND 1.00381780483e-15 ; C_M1_SUB
C$85 GND GND 8.03054243867e-15 ; C_M1_SUB
C$86 GND GND 8.03054243867e-15 ; C_M1_SUB
C$87 GND GND 5.01908902417e-15 ; C_M1_SUB
C$88 GND GND 5.01908902417e-15 ; C_M1_SUB
C$89 GND GND 8.03054243867e-15 ; C_M1_SUB
C$90 Q GND 4.01527121934e-15 ; C_M1_SUB
C$91 GND GND 8.03054243867e-15 ; C_M1_SUB
C$92 GND GND 8.03054243867e-15 ; C_M1_SUB
C$93 C GND 1.75668115846e-15 ; C_M1_SUB
C$94 \$7 GND 1.00381780483e-15 ; C_M1_SUB
C$95 \$9 GND 1.00381780483e-15 ; C_M1_SUB
C$96 CB GND 4.01527121934e-15 ; C_M1_SUB
C$97 \$12 GND 5.01908902417e-15 ; C_M1_SUB
C$98 CLK GND 4.01527121934e-15 ; C_M1_SUB
C$99 \$13 GND 8.03054243867e-15 ; C_M1_SUB
C$100 \$9 GND 4.01527121934e-15 ; C_M1_SUB
C$101 CB GND 3.0114534145e-15 ; C_M1_SUB
C$102 CLB GND 6.02290682901e-15 ; C_M1_SUB
C$103 CLB GND 1.10419958532e-14 ; C_M1_SUB
C$104 CLB GND 4.01527121934e-15 ; C_M1_SUB
C$105 CLB GND 3.76431676813e-15 ; C_M1_SUB
C$106 CLB GND 4.01527121934e-15 ; C_M1_SUB
C$107 \$9 GND 3.0114534145e-15 ; C_M1_SUB
C$108 \$9 GND 1.05400869508e-14 ; C_M1_SUB
C$109 PRB GND 4.01527121934e-15 ; C_M1_SUB
C$110 C GND 1.73158571334e-14 ; C_M1_SUB
C$111 \$7 GND 2.50954451209e-14 ; C_M1_SUB
C$112 Data GND 1.50572670725e-14 ; C_M1_SUB
C$113 CLB GND 1.27986770116e-14 ; C_M1_SUB
C$114 PRB GND 5.01908902417e-15 ; C_M1_SUB
C$115 \$13 GND 1.50572670725e-15 ; C_M1_SUB
C$116 \$13 GND 5.52099792659e-15 ; C_M1_SUB
C$117 \$9 GND 1.70649026822e-14 ; C_M1_SUB
C$118 CB GND 2.71030807305e-14 ; C_M1_SUB
C$119 \$7 GND 2.00763560967e-15 ; C_M1_SUB
C$120 Data GND 2.00763560967e-15 ; C_M1_SUB
C$121 \$7 GND 3.21221697547e-14 ; C_M1_SUB
C$122 \$7 GND 2.00763560967e-15 ; C_M1_SUB
C$123 \$10 GND 2.4091627316e-14 ; C_M1_SUB
C$124 \$9 GND 1.30496314628e-14 ; C_M1_SUB
C$125 \$10 GND 3.21221697547e-14 ; C_M1_SUB
C$126 \$12 GND 3.41298053644e-14 ; C_M1_SUB
C$127 Q GND 3.21221697547e-14 ; C_M1_SUB
C$128 \$10 GND 2.66011718281e-14 ; C_M1_SUB
C$129 \$13 GND 1.95744471943e-14 ; C_M1_SUB
C$130 QB GND 3.21221697547e-14 ; C_M1_SUB
C$131 Data VDD 2.00763560967e-15 ; C_M1_NW
C$132 \$9 VDD 3.0114534145e-15 ; C_M1_NW
C$133 \$12 VDD 3.0114534145e-15 ; C_M1_NW
C$134 \$7 VDD 3.0114534145e-15 ; C_M1_NW
C$135 \$10 VDD 3.0114534145e-15 ; C_M1_NW
C$136 Q VDD 5.01908902417e-15 ; C_M1_NW
C$137 \$12 VDD 6.02290682901e-15 ; C_M1_NW
C$138 \$13 VDD 2.25859006088e-15 ; C_M1_NW
C$139 CB VDD 1.10419958532e-14 ; C_M1_NW
C$140 \$7 VDD 1.00381780483e-14 ; C_M1_NW
C$141 \$7 VDD 1.00381780483e-14 ; C_M1_NW
C$142 \$7 VDD 5.01908902417e-15 ; C_M1_NW
C$143 \$9 VDD 6.02290682901e-15 ; C_M1_NW
C$144 \$10 VDD 7.27767908505e-15 ; C_M1_NW
C$145 \$10 VDD 1.00381780483e-14 ; C_M1_NW
C$146 \$12 VDD 8.03054243867e-15 ; C_M1_NW
C$147 Q VDD 4.01527121934e-15 ; C_M1_NW
C$148 \$13 VDD 8.28149688988e-15 ; C_M1_NW
C$149 C VDD 1.0791041402e-14 ; C_M1_NW
C$150 \$12 VDD 1.25477225604e-14 ; C_M1_NW
C$151 QB VDD 2.60992629257e-14 ; C_M1_NW
C$152 VDD VDD 5.01908902417e-15 ; C_M1_NW
C$153 VDD VDD 5.01908902417e-15 ; C_M1_NW
C$154 VDD VDD 5.01908902417e-15 ; C_M1_NW
C$155 VDD VDD 5.01908902417e-15 ; C_M1_NW
C$156 VDD VDD 5.01908902417e-15 ; C_M1_NW
C$157 Q VDD 4.01527121934e-15 ; C_M1_NW
C$158 VDD VDD 8.03054243867e-15 ; C_M1_NW
C$159 VDD VDD 1.00381780483e-15 ; C_M1_NW
C$160 VDD VDD 1.00381780483e-15 ; C_M1_NW
C$161 VDD VDD 1.00381780483e-15 ; C_M1_NW
C$162 VDD VDD 1.00381780483e-15 ; C_M1_NW
C$163 VDD VDD 1.00381780483e-15 ; C_M1_NW
C$164 VDD VDD 8.03054243867e-15 ; C_M1_NW
C$165 VDD VDD 8.03054243867e-15 ; C_M1_NW
C$166 VDD VDD 8.03054243867e-15 ; C_M1_NW
C$167 VDD VDD 3.0114534145e-15 ; C_M1_NW
C$168 VDD VDD 3.0114534145e-15 ; C_M1_NW
C$169 CLK GND 9.92279669147e-16 ; C_M2_SUB
C$170 Data GND 9.92279669147e-16 ; C_M2_SUB
C$171 Q GND 9.92279669147e-16 ; C_M2_SUB
C$172 PRB GND 9.92279669147e-16 ; C_M2_SUB
C$173 QB GND 9.92279669147e-16 ; C_M2_SUB
C$174 Q GND 2.14993928315e-15 ; C_M2_SUB
C$175 PRB GND 7.4420975186e-16 ; C_M2_SUB
C$176 PRB GND 1.157659614e-15 ; C_M2_SUB
C$177 Data GND 5.29215823545e-15 ; C_M2_SUB
C$178 \$12 GND 3.30759889716e-16 ; C_M2_SUB
C$179 \$12 GND 3.30759889716e-16 ; C_M2_SUB
C$180 \$12 GND 3.30759889716e-16 ; C_M2_SUB
C$181 \$12 GND 2.97683900744e-15 ; C_M2_SUB
C$182 \$12 GND 1.48841950372e-15 ; C_M2_SUB
C$183 \$12 GND 1.32303955886e-15 ; C_M2_SUB
C$184 \$9 GND 9.92279669147e-16 ; C_M2_SUB
C$185 CLB GND 9.92279669147e-16 ; C_M2_SUB
C$186 CLB GND 1.32303955886e-15 ; C_M2_SUB
C$187 CLB GND 1.32303955886e-15 ; C_M2_SUB
C$188 CLB GND 3.96911867659e-15 ; C_M2_SUB
C$189 CLB GND 3.30759889716e-16 ; C_M2_SUB
C$190 CLB GND 3.30759889716e-16 ; C_M2_SUB
C$191 CLB GND 6.61519779431e-16 ; C_M2_SUB
C$192 CLB GND 9.92279669147e-16 ; C_M2_SUB
C$193 CLB GND 1.32303955886e-15 ; C_M2_SUB
C$194 \$9 GND 1.32303955886e-15 ; C_M2_SUB
C$195 \$9 GND 1.24034958643e-15 ; C_M2_SUB
C$196 \$9 GND 3.30759889716e-15 ; C_M2_SUB
C$197 \$9 GND 3.63835878687e-15 ; C_M2_SUB
C$198 \$9 GND 9.92279669147e-16 ; C_M2_SUB
C$199 PRB GND 9.92279669147e-16 ; C_M2_SUB
C$200 PRB GND 2.31531922801e-15 ; C_M2_SUB
C$201 PRB GND 9.92279669147e-16 ; C_M2_SUB
C$202 PRB GND 3.30759889716e-16 ; C_M2_SUB
C$203 PRB GND 3.30759889716e-16 ; C_M2_SUB
C$204 PRB GND 3.30759889716e-16 ; C_M2_SUB
C$205 PRB GND 1.32303955886e-15 ; C_M2_SUB
C$206 PRB GND 7.4420975186e-15 ; C_M2_SUB
C$207 \$9 GND 3.30759889716e-15 ; C_M2_SUB
C$208 Data GND 3.30759889716e-16 ; C_M2_SUB
C$209 Data GND 1.98455933829e-15 ; C_M2_SUB
C$210 Data GND 9.92279669147e-16 ; C_M2_SUB
C$211 Data GND 1.65379944858e-15 ; C_M2_SUB
C$212 Data GND 1.98455933829e-15 ; C_M2_SUB
C$213 PRB GND 1.65379944858e-15 ; C_M2_SUB
C$214 PRB GND 9.92279669147e-16 ; C_M2_SUB
C$215 PRB GND 1.65379944858e-15 ; C_M2_SUB
C$216 PRB GND 3.30759889716e-16 ; C_M2_SUB
C$217 PRB GND 3.30759889716e-16 ; C_M2_SUB
C$218 PRB GND 1.57110947615e-15 ; C_M2_SUB
C$219 \$13 GND 9.92279669147e-16 ; C_M2_SUB
C$220 \$13 GND 9.92279669147e-16 ; C_M2_SUB
C$221 \$13 GND 3.30759889716e-16 ; C_M2_SUB
C$222 \$13 GND 3.30759889716e-16 ; C_M2_SUB
C$223 \$13 GND 3.30759889716e-16 ; C_M2_SUB
C$224 \$13 GND 3.30759889716e-16 ; C_M2_SUB
C$225 CLK GND 2.01763532726e-14 ; C_M2_SUB
C$226 Data GND 4.2998785663e-15 ; C_M2_SUB
C$227 \$9 GND 1.32303955886e-15 ; C_M2_SUB
C$228 PRB GND 1.48841950372e-15 ; C_M2_SUB
C$229 QB GND 2.23262925558e-14 ; C_M2_SUB
C$230 \$7 VDD 3.30759889716e-16 ; C_M2_NW
C$231 \$7 VDD 9.92279669147e-16 ; C_M2_NW
C$232 \$7 VDD 2.31531922801e-15 ; C_M2_NW
C$233 \$7 VDD 6.61519779431e-16 ; C_M2_NW
C$234 \$7 VDD 9.92279669147e-16 ; C_M2_NW
C$235 \$7 VDD 1.32303955886e-15 ; C_M2_NW
C$236 \$9 VDD 1.32303955886e-15 ; C_M2_NW
C$237 \$10 VDD 9.92279669147e-16 ; C_M2_NW
C$238 \$10 VDD 1.57110947615e-15 ; C_M2_NW
C$239 \$10 VDD 3.30759889716e-16 ; C_M2_NW
C$240 \$10 VDD 3.30759889716e-16 ; C_M2_NW
C$241 \$10 VDD 1.48841950372e-15 ; C_M2_NW
C$242 \$10 VDD 1.98455933829e-15 ; C_M2_NW
C$243 \$10 VDD 1.90186936586e-15 ; C_M2_NW
C$244 \$10 VDD 9.09589696718e-16 ; C_M2_NW
C$245 \$10 VDD 3.30759889716e-16 ; C_M2_NW
C$246 \$10 VDD 3.30759889716e-16 ; C_M2_NW
C$247 PRB VDD 3.30759889716e-16 ; C_M2_NW
C$248 PRB VDD 2.31531922801e-15 ; C_M2_NW
C$249 CLK VDD 1.43880552026e-14 ; C_M2_NW
C$250 Data VDD 7.4420975186e-15 ; C_M2_NW
C$251 Q VDD 2.14993928315e-15 ; C_M2_NW
C$252 PRB VDD 2.97683900744e-15 ; C_M2_NW
C$253 QB VDD 1.43880552026e-14 ; C_M2_NW
C$254 CLK VDD 9.92279669147e-16 ; C_M2_NW
C$255 Data VDD 9.92279669147e-16 ; C_M2_NW
C$256 Q VDD 9.92279669147e-16 ; C_M2_NW
C$257 PRB VDD 9.92279669147e-16 ; C_M2_NW
C$258 QB VDD 9.92279669147e-16 ; C_M2_NW
C$259 CLK GND 1.30800501842e-15 ; C_PO_SUB
C$260 CB GND 1.30800501842e-15 ; C_PO_SUB
C$261 CB GND 1.30800501842e-15 ; C_PO_SUB
C$262 Data GND 1.30800501842e-15 ; C_PO_SUB
C$263 \$9 GND 1.30800501842e-15 ; C_PO_SUB
C$264 CLB GND 1.30800501842e-15 ; C_PO_SUB
C$265 \$7 GND 1.30800501842e-15 ; C_PO_SUB
C$266 PRB GND 1.30800501842e-15 ; C_PO_SUB
C$267 \$9 GND 1.30800501842e-15 ; C_PO_SUB
C$268 CLB GND 1.30800501842e-15 ; C_PO_SUB
C$269 CB GND 1.30800501842e-15 ; C_PO_SUB
C$270 \$13 GND 1.30800501842e-15 ; C_PO_SUB
C$271 CLB GND 1.30800501842e-15 ; C_PO_SUB
C$272 \$12 GND 1.30800501842e-15 ; C_PO_SUB
C$273 PRB GND 1.30800501842e-15 ; C_PO_SUB
C$274 \$13 GND 1.30800501842e-15 ; C_PO_SUB
C$275 C GND 1.30800501842e-15 ; C_PO_SUB
C$276 C GND 1.30800501842e-15 ; C_PO_SUB
C$277 \$10 GND 1.30800501842e-15 ; C_PO_SUB
C$278 \$9 GND 9.81003763815e-15 ; C_PO_SUB
C$279 \$13 GND 9.81003763815e-15 ; C_PO_SUB
C$280 CLB GND 1.17720451658e-14 ; C_PO_SUB
C$281 CLB GND 7.84803011052e-15 ; C_PO_SUB
C$282 Data GND 1.43880552026e-14 ; C_PO_SUB
C$283 \$9 GND 1.50420577118e-14 ; C_PO_SUB
C$284 CLK GND 3.59701380066e-14 ; C_PO_SUB
C$285 CB GND 3.98941530618e-14 ; C_PO_SUB
C$286 \$9 GND 1.96200752763e-15 ; C_PO_SUB
C$287 CLB GND 2.55060978592e-14 ; C_PO_SUB
C$288 \$7 GND 3.30271267151e-14 ; C_PO_SUB
C$289 PRB GND 3.79321455342e-14 ; C_PO_SUB
C$290 CB GND 2.09280802947e-14 ; C_PO_SUB
C$291 C GND 1.42572547008e-13 ; C_PO_SUB
C$292 CLB GND 5.23202007368e-15 ; C_PO_SUB
C$293 \$13 GND 3.07381179329e-14 ; C_PO_SUB
C$294 \$12 GND 2.09280802947e-14 ; C_PO_SUB
C$295 \$10 GND 4.64341781539e-14 ; C_PO_SUB
C$296 PRB GND 3.53161354974e-14 ; C_PO_SUB
C$297 CLK VDD 7.19402760131e-15 ; C_PO_NW
C$298 CB VDD 7.19402760131e-15 ; C_PO_NW
C$299 C VDD 7.19402760131e-15 ; C_PO_NW
C$300 Data VDD 1.2426047675e-14 ; C_PO_NW
C$301 CB VDD 1.30800501842e-15 ; C_PO_NW
C$302 \$9 VDD 1.2426047675e-14 ; C_PO_NW
C$303 CB VDD 1.30800501842e-15 ; C_PO_NW
C$304 CLB VDD 1.76580677487e-14 ; C_PO_NW
C$305 \$7 VDD 1.14450439112e-14 ; C_PO_NW
C$306 PRB VDD 7.19402760131e-15 ; C_PO_NW
C$307 CB VDD 1.30800501842e-15 ; C_PO_NW
C$308 \$9 VDD 9.81003763815e-15 ; C_PO_NW
C$309 C VDD 7.19402760131e-15 ; C_PO_NW
C$310 CLB VDD 9.15603512894e-15 ; C_PO_NW
C$311 \$13 VDD 7.19402760131e-15 ; C_PO_NW
C$312 \$12 VDD 2.22360853131e-14 ; C_PO_NW
C$313 \$10 VDD 7.19402760131e-15 ; C_PO_NW
C$314 PRB VDD 7.19402760131e-15 ; C_PO_NW
C$315 \$13 VDD 1.17720451658e-14 ; C_PO_NW
C$316 CLK VDD 1.30800501842e-15 ; C_PO_NW
C$317 C VDD 1.30800501842e-15 ; C_PO_NW
C$318 Data VDD 1.30800501842e-15 ; C_PO_NW
C$319 \$9 VDD 1.30800501842e-15 ; C_PO_NW
C$320 CLB VDD 1.30800501842e-15 ; C_PO_NW
C$321 \$7 VDD 1.30800501842e-15 ; C_PO_NW
C$322 PRB VDD 1.30800501842e-15 ; C_PO_NW
C$323 \$9 VDD 1.30800501842e-15 ; C_PO_NW
C$324 C VDD 1.30800501842e-15 ; C_PO_NW
C$325 CLB VDD 1.30800501842e-15 ; C_PO_NW
C$326 \$13 VDD 1.30800501842e-15 ; C_PO_NW
C$327 \$12 VDD 1.30800501842e-15 ; C_PO_NW
C$328 \$10 VDD 1.30800501842e-15 ; C_PO_NW
C$329 PRB VDD 1.30800501842e-15 ; C_PO_NW
C$330 \$13 VDD 1.30800501842e-15 ; C_PO_NW
C$331 CB VDD 1.03986398964e-13 ; C_PO_NW
.ENDS FFD
