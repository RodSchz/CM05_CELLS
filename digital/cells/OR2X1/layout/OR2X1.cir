* Extracted by KLayout (CIDESI_CM05, LNunT, CIDESI)

.SUBCKT OR2X1 A B Out VDD GND
M$1 Out \$4 VDD VDD CIDPMOS L=5U W=50U AS=625P AD=625P PS=125U PD=125U
M$2 \$9 A VDD VDD CIDPMOS L=5U W=50U AS=625P AD=187.5P PS=125U PD=57.5U
M$3 \$4 B \$9 VDD CIDPMOS L=5U W=50U AS=187.5P AD=625P PS=57.5U PD=125U
M$4 Out \$4 GND GND CIDNMOS L=5U W=10U AS=125P AD=125P PS=45U PD=45U
M$5 \$4 A GND GND CIDNMOS L=5U W=10U AS=125P AD=75P PS=45U PD=25U
M$6 GND B \$4 GND CIDNMOS L=5U W=10U AS=75P AD=125P PS=25U PD=45U
.ENDS OR2X1
