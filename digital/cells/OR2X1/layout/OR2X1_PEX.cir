* Extracted by KLayout (CIDESI_CM05, LNunT, CIDESI)

.SUBCKT OR2X1 A B Out VDD GND
M$1 Out \$4 VDD VDD CIDPMOS L=5U W=50U AS=625P AD=625P PS=125U PD=125U
M$2 \$9 A VDD VDD CIDPMOS L=5U W=50U AS=625P AD=187.5P PS=125U PD=57.5U
M$3 \$4 B \$9 VDD CIDPMOS L=5U W=50U AS=187.5P AD=625P PS=57.5U PD=125U
M$4 Out \$4 GND GND CIDNMOS L=5U W=10U AS=125P AD=125P PS=45U PD=45U
M$5 \$4 A GND GND CIDNMOS L=5U W=10U AS=125P AD=75P PS=45U PD=25U
M$6 GND B \$4 GND CIDNMOS L=5U W=10U AS=75P AD=125P PS=25U PD=45U
C$7 B VDD 1.28053691303e-14 ; C_PAR_M1M2
C$8 Out VDD 2.87761104052e-15 ; C_PAR_M1M2
C$9 B GND 1.1078802506e-14 ; C_PAR_M1M2
C$10 Out GND 2.87761104052e-15 ; C_PAR_M1M2
C$11 A VDD 2.87761104052e-15 ; C_PAR_M1M2
C$12 B \$4 3.16537214458e-15 ; C_PAR_M1M2
C$13 A GND 2.87761104052e-15 ; C_PAR_M1M2
C$14 GND GND 3.0114534145e-15 ; C_M1_SUB
C$15 GND GND 3.0114534145e-15 ; C_M1_SUB
C$16 GND GND 1.70649026822e-14 ; C_M1_SUB
C$17 GND GND 1.70649026822e-14 ; C_M1_SUB
C$18 GND GND 1.70649026822e-14 ; C_M1_SUB
C$19 B GND 4.01527121934e-15 ; C_M1_SUB
C$20 A GND 1.25477225604e-15 ; C_M1_SUB
C$21 \$4 GND 1.75668115846e-14 ; C_M1_SUB
C$22 \$4 GND 4.51718012175e-15 ; C_M1_SUB
C$23 Out GND 1.60610848773e-14 ; C_M1_SUB
C$24 \$4 VDD 4.51718012175e-15 ; C_M1_NW
C$25 A VDD 2.76049896329e-15 ; C_M1_NW
C$26 \$4 VDD 5.01908902417e-15 ; C_M1_NW
C$27 Out VDD 6.02290682901e-15 ; C_M1_NW
C$28 VDD VDD 9.03436024351e-15 ; C_M1_NW
C$29 VDD VDD 9.03436024351e-15 ; C_M1_NW
C$30 VDD VDD 3.0114534145e-15 ; C_M1_NW
C$31 VDD VDD 3.0114534145e-15 ; C_M1_NW
C$32 A GND 9.92279669147e-16 ; C_M2_SUB
C$33 B GND 9.92279669147e-16 ; C_M2_SUB
C$34 Out GND 9.92279669147e-16 ; C_M2_SUB
C$35 B GND 1.07496964158e-14 ; C_M2_SUB
C$36 A GND 1.84398638516e-14 ; C_M2_SUB
C$37 Out GND 1.93494535484e-14 ; C_M2_SUB
C$38 A VDD 1.61245446236e-14 ; C_M2_NW
C$39 B VDD 8.93051702232e-15 ; C_M2_NW
C$40 Out VDD 1.73648942101e-14 ; C_M2_NW
C$41 A VDD 9.92279669147e-16 ; C_M2_NW
C$42 B VDD 9.92279669147e-16 ; C_M2_NW
C$43 Out VDD 9.92279669147e-16 ; C_M2_NW
C$44 A GND 1.30800501842e-15 ; C_PO_SUB
C$45 B GND 1.30800501842e-15 ; C_PO_SUB
C$46 \$4 GND 1.30800501842e-15 ; C_PO_SUB
C$47 A GND 1.50420577118e-14 ; C_PO_SUB
C$48 B GND 2.15820828039e-14 ; C_PO_SUB
C$49 \$4 GND 1.53690589664e-14 ; C_PO_SUB
C$50 A VDD 1.04640401474e-14 ; C_PO_NW
C$51 B VDD 5.88602258289e-15 ; C_PO_NW
C$52 \$4 VDD 8.17503136513e-15 ; C_PO_NW
C$53 A VDD 1.30800501842e-15 ; C_PO_NW
C$54 B VDD 1.30800501842e-15 ; C_PO_NW
C$55 \$4 VDD 1.30800501842e-15 ; C_PO_NW
.ENDS OR2X1
