* Extracted by KLayout (CIDESI_CM05, LNunT, CIDESI)

.SUBCKT FILLER
.ENDS FILLER
