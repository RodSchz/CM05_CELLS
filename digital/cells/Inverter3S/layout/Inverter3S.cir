* Extracted by KLayout (CIDESI_CM05, LNunT, CIDESI)

.SUBCKT Inverter3S OEB Out Data VDD GND
M$1 \$14 OEB Out VDD CIDPMOS L=5U W=25U AS=312.5P AD=93.75P PS=75U PD=32.5U
M$2 VDD Data \$14 VDD CIDPMOS L=5U W=25U AS=93.75P AD=187.5P PS=32.5U PD=40U
M$3 \$15 Data VDD VDD CIDPMOS L=5U W=25U AS=187.5P AD=93.75P PS=40U PD=32.5U
M$4 Out OEB \$15 VDD CIDPMOS L=5U W=25U AS=93.75P AD=312.5P PS=32.5U PD=75U
M$5 \$3 OEB VDD VDD CIDPMOS L=5U W=25U AS=312.5P AD=312.5P PS=75U PD=75U
M$6 \$8 \$3 Out GND CIDNMOS L=5U W=10U AS=125P AD=37.5P PS=45U PD=17.5U
M$7 GND Data \$8 GND CIDNMOS L=5U W=10U AS=37.5P AD=75P PS=17.5U PD=25U
M$8 \$10 Data GND GND CIDNMOS L=5U W=10U AS=75P AD=37.5P PS=25U PD=17.5U
M$9 Out \$3 \$10 GND CIDNMOS L=5U W=10U AS=37.5P AD=125P PS=17.5U PD=45U
M$10 \$3 OEB GND GND CIDNMOS L=5U W=10U AS=125P AD=125P PS=45U PD=45U
.ENDS Inverter3S
