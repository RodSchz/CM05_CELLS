* Extracted by KLayout (CIDESI_CM05, LNunT, CIDESI)

.SUBCKT Inverter3S OEB Out Data VDD GND
M$1 \$14 OEB Out VDD CIDPMOS L=5U W=25U AS=312.5P AD=93.75P PS=75U PD=32.5U
M$2 VDD Data \$14 VDD CIDPMOS L=5U W=25U AS=93.75P AD=187.5P PS=32.5U PD=40U
M$3 \$15 Data VDD VDD CIDPMOS L=5U W=25U AS=187.5P AD=93.75P PS=40U PD=32.5U
M$4 Out OEB \$15 VDD CIDPMOS L=5U W=25U AS=93.75P AD=312.5P PS=32.5U PD=75U
M$5 \$3 OEB VDD VDD CIDPMOS L=5U W=25U AS=312.5P AD=312.5P PS=75U PD=75U
M$6 \$8 \$3 Out GND CIDNMOS L=5U W=10U AS=125P AD=37.5P PS=45U PD=17.5U
M$7 GND Data \$8 GND CIDNMOS L=5U W=10U AS=37.5P AD=75P PS=17.5U PD=25U
M$8 \$10 Data GND GND CIDNMOS L=5U W=10U AS=75P AD=37.5P PS=25U PD=17.5U
M$9 Out \$3 \$10 GND CIDNMOS L=5U W=10U AS=37.5P AD=125P PS=17.5U PD=45U
M$10 \$3 OEB GND GND CIDNMOS L=5U W=10U AS=125P AD=125P PS=45U PD=45U
C$11 Data VDD 1.26614885783e-14 ; C_PAR_M1M2
C$12 Data Out 3.45313324863e-15 ; C_PAR_M1M2
C$13 Out VDD 2.87761104052e-15 ; C_PAR_M1M2
C$14 Data GND 1.43880552026e-14 ; C_PAR_M1M2
C$15 Out GND 2.87761104052e-15 ; C_PAR_M1M2
C$16 OEB VDD 2.87761104052e-15 ; C_PAR_M1M2
C$17 OEB GND 2.87761104052e-15 ; C_PAR_M1M2
C$18 GND GND 3.0114534145e-15 ; C_M1_SUB
C$19 GND GND 3.0114534145e-15 ; C_M1_SUB
C$20 GND GND 1.00381780483e-14 ; C_M1_SUB
C$21 GND GND 1.70649026822e-14 ; C_M1_SUB
C$22 \$3 GND 6.77577018263e-15 ; C_M1_SUB
C$23 GND GND 5.01908902417e-15 ; C_M1_SUB
C$24 Out GND 4.01527121934e-15 ; C_M1_SUB
C$25 OEB GND 4.01527121934e-15 ; C_M1_SUB
C$26 Data GND 4.01527121934e-15 ; C_M1_SUB
C$27 \$3 GND 1.70649026822e-14 ; C_M1_SUB
C$28 Out GND 1.70649026822e-14 ; C_M1_SUB
C$29 Out VDD 6.02290682901e-15 ; C_M1_NW
C$30 Out VDD 1.40534492677e-14 ; C_M1_NW
C$31 \$3 VDD 1.60610848773e-14 ; C_M1_NW
C$32 Out VDD 2.20839917064e-14 ; C_M1_NW
C$33 Out VDD 1.05400869508e-14 ; C_M1_NW
C$34 VDD VDD 5.01908902417e-15 ; C_M1_NW
C$35 VDD VDD 9.03436024351e-15 ; C_M1_NW
C$36 VDD VDD 2.00763560967e-15 ; C_M1_NW
C$37 VDD VDD 3.0114534145e-15 ; C_M1_NW
C$38 VDD VDD 3.0114534145e-15 ; C_M1_NW
C$39 OEB GND 9.92279669147e-16 ; C_M2_SUB
C$40 Data GND 9.92279669147e-16 ; C_M2_SUB
C$41 Out GND 9.92279669147e-16 ; C_M2_SUB
C$42 Data GND 8.26899724289e-16 ; C_M2_SUB
C$43 Data GND 8.26899724289e-16 ; C_M2_SUB
C$44 Data GND 4.13449862144e-16 ; C_M2_SUB
C$45 Data GND 4.13449862144e-16 ; C_M2_SUB
C$46 Data GND 1.48841950372e-15 ; C_M2_SUB
C$47 OEB GND 1.37265354232e-14 ; C_M2_SUB
C$48 OEB GND 4.96139834573e-16 ; C_M2_SUB
C$49 Data GND 2.31531922801e-15 ; C_M2_SUB
C$50 Out GND 1.71995142652e-14 ; C_M2_SUB
C$51 Data VDD 5.95367801488e-15 ; C_M2_NW
C$52 Data VDD 4.13449862144e-16 ; C_M2_NW
C$53 Data VDD 4.13449862144e-16 ; C_M2_NW
C$54 OEB VDD 1.73648942101e-14 ; C_M2_NW
C$55 Data VDD 1.65379944858e-16 ; C_M2_NW
C$56 Data VDD 1.65379944858e-16 ; C_M2_NW
C$57 Out VDD 1.157659614e-14 ; C_M2_NW
C$58 OEB VDD 2.97683900744e-15 ; C_M2_NW
C$59 Data VDD 2.97683900744e-15 ; C_M2_NW
C$60 Out VDD 2.97683900744e-15 ; C_M2_NW
C$61 OEB GND 1.30800501842e-15 ; C_PO_SUB
C$62 Data GND 1.30800501842e-15 ; C_PO_SUB
C$63 Data GND 1.30800501842e-15 ; C_PO_SUB
C$64 \$3 GND 3.20461229513e-14 ; C_PO_SUB
C$65 \$3 GND 1.30800501842e-15 ; C_PO_SUB
C$66 \$3 GND 1.30800501842e-15 ; C_PO_SUB
C$67 OEB GND 2.55060978592e-14 ; C_PO_SUB
C$68 Data GND 3.27001254605e-14 ; C_PO_SUB
C$69 OEB VDD 1.04640401474e-14 ; C_PO_NW
C$70 OEB VDD 1.30800501842e-15 ; C_PO_NW
C$71 Data VDD 1.04640401474e-14 ; C_PO_NW
C$72 Data VDD 1.04640401474e-14 ; C_PO_NW
C$73 OEB VDD 1.30800501842e-15 ; C_PO_NW
C$74 Data VDD 1.30800501842e-15 ; C_PO_NW
C$75 Data VDD 1.30800501842e-15 ; C_PO_NW
C$76 OEB VDD 3.00841154237e-14 ; C_PO_NW
.ENDS Inverter3S
