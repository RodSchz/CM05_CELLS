* C:\Users\Alexa\#Residencia_Dig\CM05_CELLS\digital\cells\NAND3X1\Ltspice\NT.asc
* Generated by LTspice 26.0.2 for Windows.
XX1 A B C Out VDD 0 NAND3X1

* block symbol definitions
.subckt NAND3X1 A B C Out VDD GND
MP1 Out A VDD VDD CIDPMOS l=5u w=50u
MP2 Out B VDD VDD CIDPMOS l=5u w=50u
MP3 Out C VDD VDD CIDPMOS l=5u w=50u
MN1 Out A n1 0 CIDNMOS l=5u w=30u
MN2 n1 B n2 0 CIDNMOS l=5u w=30u
MN3 n2 C 0 0 CIDNMOS l=5u w=30u
.ends NAND3X1

.model NMOS NMOS
.model PMOS PMOS
.lib C:\Users\Alexa\AppData\Local\LTspice\lib\cmp\standard.mos
.backanno
.end
