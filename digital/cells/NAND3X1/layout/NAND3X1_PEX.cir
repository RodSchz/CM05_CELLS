* Extracted by KLayout (CIDESI_CM05, LNunT, CIDESI)

.SUBCKT NAND3X1 Out B C A VDD GND
M$1 Out A VDD VDD CIDPMOS L=5U W=50U AS=750P AD=375P PS=130U PD=65U
M$2 VDD B Out VDD CIDPMOS L=5U W=50U AS=375P AD=375P PS=65U PD=65U
M$3 Out C VDD VDD CIDPMOS L=5U W=50U AS=375P AD=750P PS=65U PD=130U
M$4 \$6 A Out GND CIDNMOS L=5U W=30U AS=450P AD=225P PS=90U PD=45U
M$5 \$7 B \$6 GND CIDNMOS L=5U W=30U AS=225P AD=225P PS=45U PD=45U
M$6 GND C \$7 GND CIDNMOS L=5U W=30U AS=225P AD=450P PS=45U PD=90U
C$7 C VDD 8.92059422563e-15 ; C_PAR_M1M2
C$8 B VDD 2.58984993647e-15 ; C_PAR_M1M2
C$9 Out GND 2.30208883242e-15 ; C_PAR_M1M2
C$10 A GND 2.30208883242e-15 ; C_PAR_M1M2
C$11 C Out 7.33790815334e-15 ; C_PAR_M1M2
C$12 B VDD 4.60417766484e-15 ; C_PAR_M1M2
C$13 C GND 5.467460977e-15 ; C_PAR_M1M2
C$14 B Out 1.00716386418e-14 ; C_PAR_M1M2
C$15 B GND 2.87761104052e-15 ; C_PAR_M1M2
C$16 A VDD 2.58984993647e-15 ; C_PAR_M1M2
C$17 Out VDD 2.58984993647e-15 ; C_PAR_M1M2
C$18 GND GND 7.02672463384e-15 ; C_M1_SUB
C$19 GND GND 6.02290682901e-15 ; C_M1_SUB
C$20 Out GND 2.00763560967e-15 ; C_M1_SUB
C$21 GND GND 6.02290682901e-15 ; C_M1_SUB
C$22 GND GND 2.00763560967e-15 ; C_M1_SUB
C$23 A GND 4.01527121934e-15 ; C_M1_SUB
C$24 Out GND 1.30496314628e-14 ; C_M1_SUB
C$25 Out GND 6.02290682901e-15 ; C_M1_SUB
C$26 Out GND 6.02290682901e-15 ; C_M1_SUB
C$27 Out GND 6.02290682901e-15 ; C_M1_SUB
C$28 Out GND 1.10419958532e-14 ; C_M1_SUB
C$29 VDD VDD 3.0114534145e-15 ; C_M1_NW
C$30 Out VDD 6.02290682901e-15 ; C_M1_NW
C$31 VDD VDD 3.0114534145e-15 ; C_M1_NW
C$32 Out VDD 6.02290682901e-15 ; C_M1_NW
C$33 Out VDD 1.00381780483e-15 ; C_M1_NW
C$34 Out VDD 1.00381780483e-15 ; C_M1_NW
C$35 VDD VDD 5.72176148756e-14 ; C_M1_NW
C$36 A GND 6.61519779431e-16 ; C_M2_SUB
C$37 B GND 9.92279669147e-16 ; C_M2_SUB
C$38 C GND 9.92279669147e-16 ; C_M2_SUB
C$39 Out GND 6.61519779431e-16 ; C_M2_SUB
C$40 B GND 2.31531922801e-15 ; C_M2_SUB
C$41 C GND 1.81917939344e-15 ; C_M2_SUB
C$42 B GND 1.24034958643e-15 ; C_M2_SUB
C$43 B GND 4.13449862144e-16 ; C_M2_SUB
C$44 C GND 8.26899724289e-16 ; C_M2_SUB
C$45 C GND 6.61519779431e-16 ; C_M2_SUB
C$46 A GND 8.26899724289e-15 ; C_M2_SUB
C$47 B GND 7.4420975186e-16 ; C_M2_SUB
C$48 B GND 2.48069917287e-16 ; C_M2_SUB
C$49 C GND 4.96139834573e-16 ; C_M2_SUB
C$50 C GND 4.96139834573e-16 ; C_M2_SUB
C$51 Out GND 1.12458362503e-14 ; C_M2_SUB
C$52 A GND 1.32303955886e-15 ; C_M2_SUB
C$53 B VDD 4.96139834573e-16 ; C_M2_NW
C$54 B VDD 4.96139834573e-16 ; C_M2_NW
C$55 C VDD 7.4420975186e-16 ; C_M2_NW
C$56 C VDD 4.96139834573e-16 ; C_M2_NW
C$57 B VDD 1.81917939344e-15 ; C_M2_NW
C$58 A VDD 1.157659614e-14 ; C_M2_NW
C$59 B VDD 4.96139834573e-16 ; C_M2_NW
C$60 C VDD 3.1422189523e-15 ; C_M2_NW
C$61 Out VDD 1.157659614e-14 ; C_M2_NW
C$62 A VDD 1.81917939344e-15 ; C_M2_NW
C$63 B VDD 1.98455933829e-15 ; C_M2_NW
C$64 C VDD 1.98455933829e-15 ; C_M2_NW
C$65 Out VDD 1.81917939344e-15 ; C_M2_NW
C$66 A GND 2.61601003684e-15 ; C_PO_SUB
C$67 B GND 2.61601003684e-15 ; C_PO_SUB
C$68 C GND 2.61601003684e-15 ; C_PO_SUB
C$69 A GND 2.22360853131e-14 ; C_PO_SUB
C$70 B GND 2.22360853131e-14 ; C_PO_SUB
C$71 C GND 2.22360853131e-14 ; C_PO_SUB
C$72 A VDD 3.92401505526e-15 ; C_PO_NW
C$73 B VDD 3.92401505526e-15 ; C_PO_NW
C$74 C VDD 3.92401505526e-15 ; C_PO_NW
C$75 A VDD 1.96200752763e-15 ; C_PO_NW
C$76 B VDD 1.96200752763e-15 ; C_PO_NW
C$77 C VDD 1.96200752763e-15 ; C_PO_NW
.ENDS NAND3X1
