* SPICE3 file created from NAND3X1.ext - technology: scmos

.global Vdd Gnd

.subckt NAND3X1 A B C Out GND VDD
M1000 a_7000_6000.t0 A.t0 Out.t0 GND CIDNMOS w=30u l=5u
+  ad=0.225n pd=45u as=0.45n ps=90u
M1001 GND.t0 C.t0 a_11000_6000.t1 GND CIDNMOS w=30u l=5u
+  ad=0.45n pd=90u as=0.225n ps=45u
M1002 a_11000_6000.t0 B.t0 a_7000_6000.t1 GND CIDNMOS w=30u l=5u
+  ad=0.225n pd=45u as=0.225n ps=45u
M1003 Out A.t1 VDD VDD.t0 CIDPMOS w=50u l=5u
+  ad=0.375n pd=65u as=0.75n ps=0.13m
M1004 Out C.t1 VDD VDD.t3 CIDPMOS w=50u l=5u
+  ad=0.75n pd=0.13m as=0.375n ps=65u
M1005 VDD B.t1 Out VDD CIDPMOS w=50u l=5u
+  ad=0.375n pd=65u as=0.375n ps=65u
R0 Out Out.t0 1.58316
R1 C C.t1 56250
R2 C C.t0 26250
R3 B B.t1 56250
R4 B B.t0 26250
R5 A.n0 A.t1 47250
R6 A.n0 A.t0 42750
R7 A A.n0 22500.2
R8 VDD VDD.t0 31.992
R9 VDD VDD.t3 31.8039
R10 GND GND.t0 1.33321
R11 a_11000_6000.t0 a_11000_6000.t1 2.3505
R12 a_7000_6000.t0 a_7000_6000.t1 2.3505
C0 B C 0.9042f
C1 B Out 42.5121f
C2 A B 0.08753f
C3 VDD B 23.1432f
C4 C Out 28.2926f
C5 VDD C 31.7199f
C6 A Out 0.09509f
C7 VDD Out 2.72649f
C8 VDD A 2.23067f
C9 Out GND 73.04314f
C10 C GND 78.40511f
C11 B GND 72.888f
C12 A GND 5.33979f
C13 VDD GND 56.01344f
C14 a_7000_6000.t1 GND 0
C15 a_7000_6000.t0 GND 0
C16 a_11000_6000.t1 GND 0
C17 a_11000_6000.t0 GND 0
C18 VDD.t0 GND 2.48331f
C19 VDD.t3 GND 2.51192f
C20 A.t1 GND 0.20474f
C21 A.t0 GND 0.16989f
C22 A.n0 GND 0.22783f
C23 B.t1 GND 4.68322f
C24 B.t0 GND 2.86398f
C25 C.t1 GND 4.28055f
C26 C.t0 GND 2.61774f
C27 Out.t0 GND 3.70946f
.ends
