* Extracted by KLayout (CIDESI_CM05, LNunT, CIDESI)

.SUBCKT NAND3X1 A B C VDD Out GND
M$1 Out A VDD VDD CIDPMOS L=5U W=50U AS=750P AD=375P PS=130U PD=65U
M$2 VDD B Out VDD CIDPMOS L=5U W=50U AS=375P AD=375P PS=65U PD=65U
M$3 Out C VDD VDD CIDPMOS L=5U W=50U AS=375P AD=750P PS=65U PD=130U
M$4 \$11 A Out GND CIDNMOS L=5U W=30U AS=450P AD=225P PS=90U PD=45U
M$5 \$10 B \$11 GND CIDNMOS L=5U W=30U AS=225P AD=225P PS=45U PD=45U
M$6 GND C \$10 GND CIDNMOS L=5U W=30U AS=225P AD=450P PS=45U PD=90U
C$7 Out VDD 1.23326187451e-15 ; C_PAR_M1M2
C$8 C VDD 1.66490353059e-14 ; C_PAR_M1M2
C$9 C Out 1.57240889e-14 ; C_PAR_M1M2
C$10 B GND 5.5496784353e-15 ; C_PAR_M1M2
C$11 B Out 2.15820828039e-14 ; C_PAR_M1M2
C$12 C GND 1.23326187451e-14 ; C_PAR_M1M2
C$13 A GND 1.23326187451e-15 ; C_PAR_M1M2
C$14 B VDD 7.39957124706e-15 ; C_PAR_M1M2
C$15 Out GND 1.23326187451e-15 ; C_PAR_M1M2
C$16 A VDD 1.23326187451e-15 ; C_PAR_M1M2
C$17 B VDD 5.5496784353e-15 ; C_PAR_M1M2
C$18 GND GND 2.87761104052e-15 ; C_M1_SUB
C$19 GND GND 2.87761104052e-15 ; C_M1_SUB
C$20 Out GND 2.87761104052e-15 ; C_M1_SUB
C$21 GND GND 8.63283312158e-15 ; C_M1_SUB
C$22 GND GND 2.87761104052e-15 ; C_M1_SUB
C$23 A GND 5.75522208105e-15 ; C_M1_SUB
C$24 Out GND 1.87044717634e-14 ; C_M1_SUB
C$25 Out GND 6.83432622125e-15 ; C_M1_SUB
C$26 Out GND 6.47462484118e-15 ; C_M1_SUB
C$27 Out GND 6.47462484118e-15 ; C_M1_SUB
C$28 Out GND 1.15104441621e-14 ; C_M1_SUB
C$29 Out VDD 1.79850690033e-15 ; C_M1_NW
C$30 Out VDD 2.15820828039e-15 ; C_M1_NW
C$31 VDD VDD 2.87761104052e-15 ; C_M1_NW
C$32 Out VDD 9.35223588171e-15 ; C_M1_NW
C$33 VDD VDD 2.87761104052e-15 ; C_M1_NW
C$34 Out VDD 1.15104441621e-14 ; C_M1_NW
C$35 Out VDD 2.87761104052e-15 ; C_M1_NW
C$36 Out VDD 2.87761104052e-15 ; C_M1_NW
C$37 VDD VDD 4.74805821687e-14 ; C_M1_NW
C$38 VDD VDD 2.87761104052e-15 ; C_M1_NW
C$39 VDD VDD 2.87761104052e-15 ; C_M1_NW
C$40 B GND 1.67087092676e-15 ; C_M2_SUB
C$41 C GND 1.67087092676e-15 ; C_M2_SUB
C$42 B GND 3.8986988291e-15 ; C_M2_SUB
C$43 C GND 3.06326336572e-15 ; C_M2_SUB
C$44 B GND 2.08858865845e-15 ; C_M2_SUB
C$45 B GND 6.96196219482e-16 ; C_M2_SUB
C$46 C GND 1.39239243896e-15 ; C_M2_SUB
C$47 C GND 1.11391395117e-15 ; C_M2_SUB
C$48 A GND 1.67087092676e-14 ; C_M2_SUB
C$49 B GND 1.25315319507e-15 ; C_M2_SUB
C$50 B GND 4.17717731689e-16 ; C_M2_SUB
C$51 C GND 8.35435463378e-16 ; C_M2_SUB
C$52 C GND 8.35435463378e-16 ; C_M2_SUB
C$53 Out GND 2.17213220478e-14 ; C_M2_SUB
C$54 A GND 1.67087092676e-15 ; C_M2_SUB
C$55 B VDD 6.96196219482e-16 ; C_M2_NW
C$56 B VDD 6.96196219482e-16 ; C_M2_NW
C$57 C VDD 1.11391395117e-15 ; C_M2_NW
C$58 C VDD 6.96196219482e-16 ; C_M2_NW
C$59 B VDD 2.50630639013e-15 ; C_M2_NW
C$60 B VDD 2.50630639013e-15 ; C_M2_NW
C$61 C VDD 6.96196219482e-15 ; C_M2_NW
C$62 A VDD 2.50630639013e-14 ; C_M2_NW
C$63 B VDD 3.34174185351e-15 ; C_M2_NW
C$64 C VDD 3.34174185351e-15 ; C_M2_NW
C$65 Out VDD 2.45061069258e-14 ; C_M2_NW
C$66 A GND 4.31641656079e-15 ; C_PO_SUB
C$67 B GND 4.31641656079e-15 ; C_PO_SUB
C$68 C GND 4.31641656079e-15 ; C_PO_SUB
C$69 A GND 3.56104366265e-14 ; C_PO_SUB
C$70 B GND 3.56104366265e-14 ; C_PO_SUB
C$71 C GND 3.56104366265e-14 ; C_PO_SUB
C$72 A VDD 6.47462484118e-15 ; C_PO_NW
C$73 B VDD 6.47462484118e-15 ; C_PO_NW
C$74 C VDD 6.47462484118e-15 ; C_PO_NW
C$75 A VDD 4.31641656079e-15 ; C_PO_NW
C$76 B VDD 4.31641656079e-15 ; C_PO_NW
C$77 C VDD 4.31641656079e-15 ; C_PO_NW
.ENDS NAND3X1
