* Extracted by KLayout (CIDESI_CM05, LNunT, CIDESI)

.SUBCKT NAND3X1 Out B C A VDD GND
M$1 Out A VDD VDD CIDPMOS L=5U W=50U AS=750P AD=375P PS=130U PD=65U
M$2 VDD B Out VDD CIDPMOS L=5U W=50U AS=375P AD=375P PS=65U PD=65U
M$3 Out C VDD VDD CIDPMOS L=5U W=50U AS=375P AD=750P PS=65U PD=130U
M$4 \$6 A Out GND CIDNMOS L=5U W=30U AS=450P AD=225P PS=90U PD=45U
M$5 \$7 B \$6 GND CIDNMOS L=5U W=30U AS=225P AD=225P PS=45U PD=45U
M$6 GND C \$7 GND CIDNMOS L=5U W=30U AS=225P AD=450P PS=45U PD=90U
.ENDS NAND3X1
