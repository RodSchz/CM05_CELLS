* C:\Users\Alexa\CM05_CELLS\digital\cells\NOR3X1\ltspice\NOR3X1_sch_tb.asc
* Generated by LTspice 26.0.2 for Windows.
XX1 A B C OUT VDD 0 NOR3X1_sch
V1 VDD 0 5
V2 A 0 PULSE(0 5 {T0/2} 1n 1n {T0/2} {T0})
V3 B 0 PULSE(0 5 {T0/4} 1n 1n {T0/4} {T0/2})
V4 C 0 PULSE(0 5 {T0/8} 1n 1n {T0/8} {T0/4})

* block symbol definitions
.subckt NOR3X1_sch A B C OUT VDD VSS
MP1 VDD A n1 VDD CIDPMOS l=5u w=37.5u
MP2 n1 B n2 VDD CIDPMOS l=5u w=37.5u
MP3 n2 C OUT VDD CIDPMOS l=5u w=37.5u
MN1 OUT A VSS VSS CIDNMOS l=5u w=10u
MN2 OUT B VSS VSS CIDNMOS l=5u w=10u
MN3 OUT C VSS VSS CIDNMOS l=5u w=10u
.ends NOR3X1_sch

.model NMOS NMOS
.model PMOS PMOS
.lib C:\Users\Alexa\AppData\Local\LTspice\lib\cmp\standard.mos
.options gmin=1e-10
.options abstol=1e-10
.options reltol=0.003
.options cshunt=1e-15
.inc ..\..\..\..\pdk\tech\models\CM05_models.lib
.param f0=1MEG T0=1/f0
.tran 0 {2*T0} 0 10n
.backanno
.end
