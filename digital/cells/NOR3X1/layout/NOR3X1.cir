* Extracted by KLayout (CIDESI_CM05, LNunT, CIDESI)

.SUBCKT NOR3X1 A B C VDD OUT VSS
M$1 \$11 A VDD VDD CIDPMOS L=5U W=37.5U AS=562.5P AD=281.25P PS=105U PD=52.5U
M$2 \$10 B \$11 VDD CIDPMOS L=5U W=37.5U AS=281.25P AD=281.25P PS=52.5U PD=52.5U
M$3 OUT C \$10 VDD CIDPMOS L=5U W=37.5U AS=281.25P AD=562.5P PS=52.5U PD=105U
M$4 OUT A VSS VSS CIDNMOS L=5U W=10U AS=150P AD=75P PS=50U PD=25U
M$5 VSS B OUT VSS CIDNMOS L=5U W=10U AS=75P AD=75P PS=25U PD=25U
M$6 OUT C VSS VSS CIDNMOS L=5U W=10U AS=75P AD=150P PS=25U PD=50U
.ENDS NOR3X1
