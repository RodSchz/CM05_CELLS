* Extracted by KLayout (CIDESI_CM05, LNunT, CIDESI)

.SUBCKT NOR3X1 A B C VDD OUT GND
M$1 \$11 A VDD VDD CIDPMOS L=5U W=37.5U AS=562.5P AD=281.25P PS=105U PD=52.5U
M$2 \$10 B \$11 VDD CIDPMOS L=5U W=37.5U AS=281.25P AD=281.25P PS=52.5U PD=52.5U
M$3 OUT C \$10 VDD CIDPMOS L=5U W=37.5U AS=281.25P AD=562.5P PS=52.5U PD=105U
M$4 OUT A GND GND CIDNMOS L=5U W=10U AS=150P AD=75P PS=50U PD=25U
M$5 GND B OUT GND CIDNMOS L=5U W=10U AS=75P AD=75P PS=25U PD=25U
M$6 OUT C GND GND CIDNMOS L=5U W=10U AS=75P AD=150P PS=25U PD=50U
C$7 C VDD 6.16630937255e-15 ; C_PAR_M1M2
C$8 B VDD 1.84989281177e-14 ; C_PAR_M1M2
C$9 A VDD 4.31641656079e-15 ; C_PAR_M1M2
C$10 C OUT 1.04827259333e-14 ; C_PAR_M1M2
C$11 OUT VDD 4.31641656079e-15 ; C_PAR_M1M2
C$12 C OUT 1.10993568706e-14 ; C_PAR_M1M2
C$13 OUT GND 4.31641656079e-15 ; C_PAR_M1M2
C$14 B GND 1.29492496824e-14 ; C_PAR_M1M2
C$15 C GND 6.16630937255e-15 ; C_PAR_M1M2
C$16 A GND 4.31641656079e-15 ; C_PAR_M1M2
C$17 GND GND 1.15104441621e-14 ; C_M1_SUB
C$18 GND GND 1.15104441621e-14 ; C_M1_SUB
C$19 OUT GND 1.15104441621e-14 ; C_M1_SUB
C$20 OUT GND 8.63283312158e-15 ; C_M1_SUB
C$21 B GND 2.15820828039e-15 ; C_M1_SUB
C$22 B GND 2.15820828039e-15 ; C_M1_SUB
C$23 B GND 8.63283312158e-15 ; C_M1_SUB
C$24 C GND 2.15820828039e-15 ; C_M1_SUB
C$25 C GND 5.75522208105e-15 ; C_M1_SUB
C$26 A GND 1.15104441621e-14 ; C_M1_SUB
C$27 OUT GND 5.17969987294e-14 ; C_M1_SUB
C$28 OUT VDD 2.58984993647e-14 ; C_M1_NW
C$29 VDD VDD 1.15104441621e-14 ; C_M1_NW
C$30 B GND 1.67087092676e-15 ; C_M2_SUB
C$31 C GND 1.67087092676e-15 ; C_M2_SUB
C$32 B GND 3.62022034131e-15 ; C_M2_SUB
C$33 C GND 5.84804824365e-15 ; C_M2_SUB
C$34 C GND 4.17717731689e-16 ; C_M2_SUB
C$35 C GND 4.17717731689e-16 ; C_M2_SUB
C$36 C GND 6.96196219482e-16 ; C_M2_SUB
C$37 C GND 2.08858865845e-15 ; C_M2_SUB
C$38 A GND 2.36706714624e-14 ; C_M2_SUB
C$39 B GND 5.43033051196e-15 ; C_M2_SUB
C$40 B GND 1.81011017065e-15 ; C_M2_SUB
C$41 OUT GND 1.11391395117e-15 ; C_M2_SUB
C$42 OUT GND 1.69871877554e-14 ; C_M2_SUB
C$43 A GND 1.67087092676e-15 ; C_M2_SUB
C$44 B GND 3.34174185351e-15 ; C_M2_SUB
C$45 B GND 1.11391395117e-15 ; C_M2_SUB
C$46 C GND 4.17717731689e-16 ; C_M2_SUB
C$47 C GND 1.25315319507e-15 ; C_M2_SUB
C$48 OUT GND 8.35435463378e-16 ; C_M2_SUB
C$49 OUT GND 8.35435463378e-16 ; C_M2_SUB
C$50 OUT VDD 9.74674707275e-16 ; C_M2_NW
C$51 B VDD 5.01261278027e-15 ; C_M2_NW
C$52 B VDD 1.67087092676e-15 ; C_M2_NW
C$53 C VDD 1.67087092676e-15 ; C_M2_NW
C$54 C VDD 3.62022034131e-15 ; C_M2_NW
C$55 B VDD 3.62022034131e-15 ; C_M2_NW
C$56 C VDD 5.84804824365e-15 ; C_M2_NW
C$57 A VDD 3.45313324863e-14 ; C_M2_NW
C$58 B VDD 4.17717731689e-15 ; C_M2_NW
C$59 C VDD 4.17717731689e-15 ; C_M2_NW
C$60 OUT VDD 2.6873174072e-14 ; C_M2_NW
C$61 A GND 3.23731242059e-15 ; C_PO_SUB
C$62 B GND 3.23731242059e-15 ; C_PO_SUB
C$63 C GND 3.23731242059e-15 ; C_PO_SUB
C$64 A GND 5.28761028696e-14 ; C_PO_SUB
C$65 B GND 3.99268531873e-14 ; C_PO_SUB
C$66 C GND 3.99268531873e-14 ; C_PO_SUB
C$67 A VDD 1.29492496824e-14 ; C_PO_NW
C$68 B VDD 1.29492496824e-14 ; C_PO_NW
C$69 C VDD 1.29492496824e-14 ; C_PO_NW
C$70 A VDD 3.23731242059e-15 ; C_PO_NW
C$71 B VDD 3.23731242059e-15 ; C_PO_NW
C$72 C VDD 3.23731242059e-15 ; C_PO_NW
.ENDS NOR3X1
