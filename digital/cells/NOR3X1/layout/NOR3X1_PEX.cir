* Extracted by KLayout (CIDESI_CM05, LNunT, CIDESI)

.SUBCKT NOR3X1 A B C VDD OUT VSS
M$1 \$11 A VDD VDD CIDPMOS L=5U W=37.5U AS=562.5P AD=281.25P PS=105U PD=52.5U
M$2 \$10 B \$11 VDD CIDPMOS L=5U W=37.5U AS=281.25P AD=281.25P PS=52.5U PD=52.5U
M$3 OUT C \$10 VDD CIDPMOS L=5U W=37.5U AS=281.25P AD=562.5P PS=52.5U PD=105U
M$4 OUT A VSS VSS CIDNMOS L=5U W=10U AS=150P AD=75P PS=50U PD=25U
M$5 VSS B OUT VSS CIDNMOS L=5U W=10U AS=75P AD=75P PS=25U PD=25U
M$6 OUT C VSS VSS CIDNMOS L=5U W=10U AS=75P AD=150P PS=25U PD=50U
C$7 OUT VDD 1.84989281177e-15 ; C_PAR_M1M2
C$8 C VDD 6.16630937255e-15 ; C_PAR_M1M2
C$9 B VDD 1.84989281177e-14 ; C_PAR_M1M2
C$10 B VSS 1.23326187451e-14 ; C_PAR_M1M2
C$11 OUT VSS 1.84989281177e-15 ; C_PAR_M1M2
C$12 A VDD 1.84989281177e-15 ; C_PAR_M1M2
C$13 C OUT 1.10993568706e-14 ; C_PAR_M1M2
C$14 C VSS 6.16630937255e-15 ; C_PAR_M1M2
C$15 C OUT 1.04827259333e-14 ; C_PAR_M1M2
C$16 A VSS 1.84989281177e-15 ; C_PAR_M1M2
C$17 VSS VSS 8.63283312158e-15 ; C_M1_SUB
C$18 VSS VSS 8.63283312158e-15 ; C_M1_SUB
C$19 OUT VSS 1.15104441621e-14 ; C_M1_SUB
C$20 OUT VSS 8.63283312158e-15 ; C_M1_SUB
C$21 B VSS 2.15820828039e-15 ; C_M1_SUB
C$22 B VSS 2.15820828039e-15 ; C_M1_SUB
C$23 B VSS 8.63283312158e-15 ; C_M1_SUB
C$24 A VSS 1.15104441621e-14 ; C_M1_SUB
C$25 C VSS 2.15820828039e-15 ; C_M1_SUB
C$26 C VSS 5.75522208105e-15 ; C_M1_SUB
C$27 OUT VSS 4.46029711281e-14 ; C_M1_SUB
C$28 OUT VDD 2.01432772837e-14 ; C_M1_NW
C$29 VDD VDD 1.00716386418e-14 ; C_M1_NW
C$30 B VSS 1.67087092676e-15 ; C_M2_SUB
C$31 C VSS 1.67087092676e-15 ; C_M2_SUB
C$32 B VSS 2.78478487793e-15 ; C_M2_SUB
C$33 C VSS 4.45565580468e-15 ; C_M2_SUB
C$34 C VSS 4.17717731689e-16 ; C_M2_SUB
C$35 C VSS 4.17717731689e-16 ; C_M2_SUB
C$36 A VSS 2.17213220478e-14 ; C_M2_SUB
C$37 B VSS 4.17717731689e-15 ; C_M2_SUB
C$38 B VSS 1.39239243896e-15 ; C_M2_SUB
C$39 C VSS 4.17717731689e-16 ; C_M2_SUB
C$40 C VSS 1.25315319507e-15 ; C_M2_SUB
C$41 OUT VSS 4.17717731689e-16 ; C_M2_SUB
C$42 OUT VSS 1.68479485115e-14 ; C_M2_SUB
C$43 B VSS 2.50630639013e-15 ; C_M2_SUB
C$44 B VSS 8.35435463378e-16 ; C_M2_SUB
C$45 OUT VSS 8.35435463378e-16 ; C_M2_SUB
C$46 OUT VSS 8.35435463378e-16 ; C_M2_SUB
C$47 OUT VDD 4.17717731689e-16 ; C_M2_NW
C$48 B VDD 3.34174185351e-15 ; C_M2_NW
C$49 B VDD 1.11391395117e-15 ; C_M2_NW
C$50 C VDD 1.11391395117e-15 ; C_M2_NW
C$51 C VDD 1.94934941455e-15 ; C_M2_NW
C$52 B VDD 3.34174185351e-15 ; C_M2_NW
C$53 C VDD 5.29109126806e-15 ; C_M2_NW
C$54 A VDD 3.17465476084e-14 ; C_M2_NW
C$55 B VDD 3.34174185351e-15 ; C_M2_NW
C$56 C VDD 3.34174185351e-15 ; C_M2_NW
C$57 OUT VDD 2.6873174072e-14 ; C_M2_NW
C$58 A VSS 2.15820828039e-15 ; C_PO_SUB
C$59 B VSS 2.15820828039e-15 ; C_PO_SUB
C$60 C VSS 2.15820828039e-15 ; C_PO_SUB
C$61 A VSS 4.74805821687e-14 ; C_PO_SUB
C$62 B VSS 3.45313324863e-14 ; C_PO_SUB
C$63 C VSS 3.45313324863e-14 ; C_PO_SUB
C$64 A VDD 8.63283312158e-15 ; C_PO_NW
C$65 B VDD 8.63283312158e-15 ; C_PO_NW
C$66 C VDD 8.63283312158e-15 ; C_PO_NW
C$67 A VDD 2.15820828039e-15 ; C_PO_NW
C$68 B VDD 2.15820828039e-15 ; C_PO_NW
C$69 C VDD 2.15820828039e-15 ; C_PO_NW
.ENDS NOR3X1
