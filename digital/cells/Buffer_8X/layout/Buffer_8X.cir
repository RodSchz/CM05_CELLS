* Extracted by KLayout (CIDESI_CM05, LNunT, CIDESI)

.SUBCKT Buffer_8X VDD A Out GND
M$1 VDD A \$5 VDD CIDPMOS L=5U W=25U AS=312.5P AD=187.5P PS=75U PD=40U
M$2 Out \$5 VDD VDD CIDPMOS L=5U W=25U AS=187.5P AD=187.5P PS=40U PD=40U
M$3 VDD \$5 Out VDD CIDPMOS L=5U W=25U AS=187.5P AD=187.5P PS=40U PD=40U
M$4 Out \$5 VDD VDD CIDPMOS L=5U W=25U AS=187.5P AD=187.5P PS=40U PD=40U
M$5 VDD \$5 Out VDD CIDPMOS L=5U W=25U AS=187.5P AD=187.5P PS=40U PD=40U
M$6 Out \$5 VDD VDD CIDPMOS L=5U W=25U AS=187.5P AD=187.5P PS=40U PD=40U
M$7 VDD \$5 Out VDD CIDPMOS L=5U W=25U AS=187.5P AD=187.5P PS=40U PD=40U
M$8 Out \$5 VDD VDD CIDPMOS L=5U W=25U AS=187.5P AD=187.5P PS=40U PD=40U
M$9 VDD \$5 Out VDD CIDPMOS L=5U W=25U AS=187.5P AD=312.5P PS=40U PD=75U
M$10 GND A \$5 GND CIDNMOS L=5U W=10U AS=125P AD=75P PS=45U PD=25U
M$11 Out \$5 GND GND CIDNMOS L=5U W=10U AS=75P AD=75P PS=25U PD=25U
M$12 GND \$5 Out GND CIDNMOS L=5U W=10U AS=75P AD=75P PS=25U PD=25U
M$13 Out \$5 GND GND CIDNMOS L=5U W=10U AS=75P AD=75P PS=25U PD=25U
M$14 GND \$5 Out GND CIDNMOS L=5U W=10U AS=75P AD=75P PS=25U PD=25U
M$15 Out \$5 GND GND CIDNMOS L=5U W=10U AS=75P AD=75P PS=25U PD=25U
M$16 GND \$5 Out GND CIDNMOS L=5U W=10U AS=75P AD=75P PS=25U PD=25U
M$17 Out \$5 GND GND CIDNMOS L=5U W=10U AS=75P AD=75P PS=25U PD=25U
M$18 GND \$5 Out GND CIDNMOS L=5U W=10U AS=75P AD=125P PS=25U PD=45U
.ENDS Buffer_8X
