* Extracted by KLayout (CIDESI_CM05, LNunT, CIDESI)

.SUBCKT Buffer_8X VDD A Out GND
M$1 VDD A \$5 VDD CIDPMOS L=5U W=25U AS=312.5P AD=187.5P PS=75U PD=40U
M$2 Out \$5 VDD VDD CIDPMOS L=5U W=25U AS=187.5P AD=187.5P PS=40U PD=40U
M$3 VDD \$5 Out VDD CIDPMOS L=5U W=25U AS=187.5P AD=187.5P PS=40U PD=40U
M$4 Out \$5 VDD VDD CIDPMOS L=5U W=25U AS=187.5P AD=187.5P PS=40U PD=40U
M$5 VDD \$5 Out VDD CIDPMOS L=5U W=25U AS=187.5P AD=187.5P PS=40U PD=40U
M$6 Out \$5 VDD VDD CIDPMOS L=5U W=25U AS=187.5P AD=187.5P PS=40U PD=40U
M$7 VDD \$5 Out VDD CIDPMOS L=5U W=25U AS=187.5P AD=187.5P PS=40U PD=40U
M$8 Out \$5 VDD VDD CIDPMOS L=5U W=25U AS=187.5P AD=187.5P PS=40U PD=40U
M$9 VDD \$5 Out VDD CIDPMOS L=5U W=25U AS=187.5P AD=312.5P PS=40U PD=75U
M$10 GND A \$5 GND CIDNMOS L=5U W=10U AS=125P AD=75P PS=45U PD=25U
M$11 Out \$5 GND GND CIDNMOS L=5U W=10U AS=75P AD=75P PS=25U PD=25U
M$12 GND \$5 Out GND CIDNMOS L=5U W=10U AS=75P AD=75P PS=25U PD=25U
M$13 Out \$5 GND GND CIDNMOS L=5U W=10U AS=75P AD=75P PS=25U PD=25U
M$14 GND \$5 Out GND CIDNMOS L=5U W=10U AS=75P AD=75P PS=25U PD=25U
M$15 Out \$5 GND GND CIDNMOS L=5U W=10U AS=75P AD=75P PS=25U PD=25U
M$16 GND \$5 Out GND CIDNMOS L=5U W=10U AS=75P AD=75P PS=25U PD=25U
M$17 Out \$5 GND GND CIDNMOS L=5U W=10U AS=75P AD=75P PS=25U PD=25U
M$18 GND \$5 Out GND CIDNMOS L=5U W=10U AS=75P AD=125P PS=25U PD=45U
C$19 Out VDD 2.87761104052e-15 ; C_PAR_M1M2
C$20 A VDD 2.87761104052e-15 ; C_PAR_M1M2
C$21 Out GND 2.58984993647e-15 ; C_PAR_M1M2
C$22 A GND 2.87761104052e-15 ; C_PAR_M1M2
C$23 GND GND 3.0114534145e-15 ; C_M1_SUB
C$24 GND GND 3.0114534145e-15 ; C_M1_SUB
C$25 GND GND 1.8068720487e-14 ; C_M1_SUB
C$26 GND GND 1.8068720487e-14 ; C_M1_SUB
C$27 GND GND 1.8068720487e-14 ; C_M1_SUB
C$28 GND GND 1.8068720487e-14 ; C_M1_SUB
C$29 GND GND 1.8068720487e-14 ; C_M1_SUB
C$30 \$5 GND 1.00381780483e-15 ; C_M1_SUB
C$31 A GND 4.01527121934e-15 ; C_M1_SUB
C$32 \$5 GND 1.50572670725e-14 ; C_M1_SUB
C$33 Out GND 1.60610848773e-14 ; C_M1_SUB
C$34 Out GND 1.60610848773e-14 ; C_M1_SUB
C$35 Out GND 1.60610848773e-14 ; C_M1_SUB
C$36 Out GND 1.60610848773e-14 ; C_M1_SUB
C$37 \$5 VDD 1.00381780483e-14 ; C_M1_NW
C$38 \$5 VDD 1.00381780483e-15 ; C_M1_NW
C$39 Out VDD 9.03436024351e-15 ; C_M1_NW
C$40 Out VDD 9.03436024351e-15 ; C_M1_NW
C$41 Out VDD 9.03436024351e-15 ; C_M1_NW
C$42 Out VDD 9.03436024351e-15 ; C_M1_NW
C$43 VDD VDD 1.50572670725e-14 ; C_M1_NW
C$44 VDD VDD 1.50572670725e-14 ; C_M1_NW
C$45 VDD VDD 1.50572670725e-14 ; C_M1_NW
C$46 VDD VDD 1.50572670725e-14 ; C_M1_NW
C$47 VDD VDD 1.50572670725e-14 ; C_M1_NW
C$48 VDD VDD 3.0114534145e-15 ; C_M1_NW
C$49 VDD VDD 3.0114534145e-15 ; C_M1_NW
C$50 A GND 9.92279669147e-16 ; C_M2_SUB
C$51 Out GND 9.92279669147e-16 ; C_M2_SUB
C$52 A GND 1.62899245685e-14 ; C_M2_SUB
C$53 Out GND 3.96911867659e-15 ; C_M2_SUB
C$54 Out GND 3.96911867659e-15 ; C_M2_SUB
C$55 Out GND 3.96911867659e-15 ; C_M2_SUB
C$56 A GND 9.09589696718e-16 ; C_M2_SUB
C$57 Out GND 2.23262925558e-14 ; C_M2_SUB
C$58 A VDD 1.68687543755e-14 ; C_M2_NW
C$59 Out VDD 1.68687543755e-14 ; C_M2_NW
C$60 A VDD 9.92279669147e-16 ; C_M2_NW
C$61 Out VDD 9.92279669147e-16 ; C_M2_NW
C$62 A GND 1.30800501842e-15 ; C_PO_SUB
C$63 \$5 GND 7.84803011052e-15 ; C_PO_SUB
C$64 \$5 GND 7.84803011052e-15 ; C_PO_SUB
C$65 \$5 GND 7.84803011052e-15 ; C_PO_SUB
C$66 \$5 GND 7.84803011052e-15 ; C_PO_SUB
C$67 \$5 GND 1.30800501842e-15 ; C_PO_SUB
C$68 \$5 GND 7.84803011052e-15 ; C_PO_SUB
C$69 \$5 GND 7.84803011052e-15 ; C_PO_SUB
C$70 \$5 GND 7.84803011052e-15 ; C_PO_SUB
C$71 A GND 2.09280802947e-14 ; C_PO_SUB
C$72 \$5 GND 1.96200752763e-14 ; C_PO_SUB
C$73 A VDD 9.15603512894e-15 ; C_PO_NW
C$74 \$5 VDD 5.88602258289e-15 ; C_PO_NW
C$75 \$5 VDD 7.84803011052e-15 ; C_PO_NW
C$76 \$5 VDD 7.84803011052e-15 ; C_PO_NW
C$77 \$5 VDD 7.84803011052e-15 ; C_PO_NW
C$78 \$5 VDD 1.30800501842e-15 ; C_PO_NW
C$79 A VDD 1.30800501842e-15 ; C_PO_NW
C$80 \$5 VDD 7.84803011052e-15 ; C_PO_NW
C$81 \$5 VDD 7.84803011052e-15 ; C_PO_NW
C$82 \$5 VDD 7.84803011052e-15 ; C_PO_NW
C$83 \$5 VDD 7.84803011052e-15 ; C_PO_NW
.ENDS Buffer_8X
