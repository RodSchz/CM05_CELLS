* Extracted by KLayout (CIDESI_CM05, LNunT, CIDESI)

.SUBCKT NOR2X1 VDD A B Out GND
M$1 \$9 A VDD VDD CIDPMOS L=5U W=50U AS=625P AD=187.5P PS=125U PD=57.5U
M$2 Out B \$9 VDD CIDPMOS L=5U W=50U AS=187.5P AD=625P PS=57.5U PD=125U
M$3 Out A GND GND CIDNMOS L=5U W=10U AS=125P AD=75P PS=45U PD=25U
M$4 GND B Out GND CIDNMOS L=5U W=10U AS=75P AD=125P PS=25U PD=45U
.ENDS NOR2X1
