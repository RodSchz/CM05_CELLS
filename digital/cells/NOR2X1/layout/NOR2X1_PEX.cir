* Extracted by KLayout (CIDESI_CM05, LNunT, CIDESI)

.SUBCKT NOR2X1 VDD A B Out GND
M$1 \$9 A VDD VDD CIDPMOS L=5U W=50U AS=625P AD=187.5P PS=125U PD=57.5U
M$2 Out B \$9 VDD CIDPMOS L=5U W=50U AS=187.5P AD=625P PS=57.5U PD=125U
M$3 Out A GND GND CIDNMOS L=5U W=10U AS=125P AD=75P PS=45U PD=25U
M$4 GND B Out GND CIDNMOS L=5U W=10U AS=75P AD=125P PS=25U PD=45U
C$5 Out VDD 2.87761104052e-15 ; C_PAR_M1M2
C$6 A VDD 2.87761104052e-15 ; C_PAR_M1M2
C$7 B VDD 2.87761104052e-15 ; C_PAR_M1M2
C$8 B GND 2.87761104052e-15 ; C_PAR_M1M2
C$9 Out GND 2.87761104052e-15 ; C_PAR_M1M2
C$10 A GND 2.87761104052e-15 ; C_PAR_M1M2
C$11 GND GND 3.0114534145e-15 ; C_M1_SUB
C$12 GND GND 3.0114534145e-15 ; C_M1_SUB
C$13 GND GND 1.70649026822e-14 ; C_M1_SUB
C$14 GND GND 1.70649026822e-14 ; C_M1_SUB
C$15 B GND 4.01527121934e-15 ; C_M1_SUB
C$16 A GND 1.25477225604e-15 ; C_M1_SUB
C$17 Out GND 1.60610848773e-14 ; C_M1_SUB
C$18 A VDD 2.76049896329e-15 ; C_M1_NW
C$19 Out VDD 4.51718012175e-15 ; C_M1_NW
C$20 VDD VDD 9.03436024351e-15 ; C_M1_NW
C$21 VDD VDD 3.0114534145e-15 ; C_M1_NW
C$22 VDD VDD 3.0114534145e-15 ; C_M1_NW
C$23 A GND 9.92279669147e-16 ; C_M2_SUB
C$24 Out GND 9.92279669147e-16 ; C_M2_SUB
C$25 B GND 9.92279669147e-16 ; C_M2_SUB
C$26 Out GND 8.43437718775e-15 ; C_M2_SUB
C$27 A GND 1.84398638516e-14 ; C_M2_SUB
C$28 Out GND 1.40572953129e-15 ; C_M2_SUB
C$29 Out GND 1.40572953129e-15 ; C_M2_SUB
C$30 B GND 1.71995142652e-14 ; C_M2_SUB
C$31 Out VDD 2.48069917287e-16 ; C_M2_NW
C$32 Out VDD 4.96139834573e-16 ; C_M2_NW
C$33 A VDD 1.61245446236e-14 ; C_M2_NW
C$34 Out VDD 4.13449862144e-15 ; C_M2_NW
C$35 B VDD 1.73648942101e-14 ; C_M2_NW
C$36 A VDD 9.92279669147e-16 ; C_M2_NW
C$37 Out VDD 9.92279669147e-16 ; C_M2_NW
C$38 B VDD 9.92279669147e-16 ; C_M2_NW
C$39 A GND 1.30800501842e-15 ; C_PO_SUB
C$40 B GND 1.30800501842e-15 ; C_PO_SUB
C$41 A GND 1.50420577118e-14 ; C_PO_SUB
C$42 B GND 2.15820828039e-14 ; C_PO_SUB
C$43 A VDD 1.04640401474e-14 ; C_PO_NW
C$44 B VDD 5.88602258289e-15 ; C_PO_NW
C$45 A VDD 1.30800501842e-15 ; C_PO_NW
C$46 B VDD 1.30800501842e-15 ; C_PO_NW
.ENDS NOR2X1
