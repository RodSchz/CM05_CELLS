* Extracted by KLayout (CIDESI_CM05, LNunT, CIDESI)

.SUBCKT XOR2X1 B Out A VDD GND
M$1 \$10 A VDD VDD CIDPMOS L=5U W=50U AS=625P AD=375P PS=125U PD=65U
M$2 VDD B \$10 VDD CIDPMOS L=5U W=50U AS=375P AD=625P PS=65U PD=125U
M$3 \$12 A VDD VDD CIDPMOS L=5U W=50U AS=625P AD=187.5P PS=125U PD=57.5U
M$4 \$4 B \$12 VDD CIDPMOS L=5U W=50U AS=187.5P AD=625P PS=57.5U PD=125U
M$5 Out \$4 \$10 VDD CIDPMOS L=5U W=50U AS=625P AD=625P PS=125U PD=125U
M$6 \$6 A GND GND CIDNMOS L=5U W=15U AS=187.5P AD=56.25P PS=55U PD=22.5U
M$7 Out B \$6 GND CIDNMOS L=5U W=15U AS=56.25P AD=187.5P PS=22.5U PD=55U
M$8 Out \$4 GND GND CIDNMOS L=5U W=10U AS=125P AD=125P PS=45U PD=45U
M$9 \$4 A GND GND CIDNMOS L=5U W=10U AS=125P AD=75P PS=45U PD=25U
M$10 GND B \$4 GND CIDNMOS L=5U W=10U AS=75P AD=125P PS=25U PD=45U
C$11 Out VDD 4.60417766484e-15 ; C_PAR_M1M2
C$12 B VDD 1.84167106594e-14 ; C_PAR_M1M2
C$13 A VDD 4.60417766484e-15 ; C_PAR_M1M2
C$14 B \$4 3.45313324863e-15 ; C_PAR_M1M2
C$15 B GND 1.26614885783e-14 ; C_PAR_M1M2
C$16 Out GND 4.60417766484e-15 ; C_PAR_M1M2
C$17 A GND 4.60417766484e-15 ; C_PAR_M1M2
C$18 B GND 1.30496314628e-14 ; C_M1_SUB
C$19 GND GND 8.33168778012e-14 ; C_M1_SUB
C$20 GND GND 8.03054243867e-15 ; C_M1_SUB
C$21 Out GND 4.01527121934e-15 ; C_M1_SUB
C$22 \$4 GND 1.35515403653e-14 ; C_M1_SUB
C$23 \$4 GND 9.03436024351e-15 ; C_M1_SUB
C$24 A GND 5.01908902417e-15 ; C_M1_SUB
C$25 \$4 GND 1.8068720487e-14 ; C_M1_SUB
C$26 \$10 GND 1.00381780483e-15 ; C_M1_SUB
C$27 \$10 GND 1.00381780483e-15 ; C_M1_SUB
C$28 Out GND 1.60610848773e-14 ; C_M1_SUB
C$29 \$4 VDD 3.76431676813e-15 ; C_M1_NW
C$30 \$4 VDD 2.50954451209e-16 ; C_M1_NW
C$31 \$10 VDD 5.01908902417e-15 ; C_M1_NW
C$32 \$10 VDD 5.01908902417e-15 ; C_M1_NW
C$33 Out VDD 6.02290682901e-15 ; C_M1_NW
C$34 VDD VDD 5.01908902417e-15 ; C_M1_NW
C$35 VDD VDD 5.92252504852e-14 ; C_M1_NW
C$36 A GND 4.96139834573e-16 ; C_M2_SUB
C$37 B GND 4.96139834573e-16 ; C_M2_SUB
C$38 Out GND 4.96139834573e-16 ; C_M2_SUB
C$39 B GND 6.78057773917e-15 ; C_M2_SUB
C$40 B GND 1.57110947615e-15 ; C_M2_SUB
C$41 Out GND 2.97683900744e-15 ; C_M2_SUB
C$42 Out GND 3.30759889716e-16 ; C_M2_SUB
C$43 B GND 3.88642870416e-15 ; C_M2_SUB
C$44 A GND 1.67033744306e-14 ; C_M2_SUB
C$45 B GND 1.98455933829e-15 ; C_M2_SUB
C$46 \$10 GND 8.26899724289e-17 ; C_M2_SUB
C$47 \$10 GND 7.4420975186e-16 ; C_M2_SUB
C$48 Out GND 1.88533137138e-14 ; C_M2_SUB
C$49 \$10 VDD 2.48069917287e-16 ; C_M2_NW
C$50 \$10 VDD 2.23262925558e-15 ; C_M2_NW
C$51 B VDD 7.11133762888e-15 ; C_M2_NW
C$52 A VDD 1.68687543755e-14 ; C_M2_NW
C$53 B VDD 1.65379944858e-16 ; C_M2_NW
C$54 Out VDD 1.68687543755e-14 ; C_M2_NW
C$55 A VDD 2.48069917287e-15 ; C_M2_NW
C$56 B VDD 2.48069917287e-15 ; C_M2_NW
C$57 Out VDD 2.48069917287e-15 ; C_M2_NW
C$58 B GND 1.37340526934e-14 ; C_PO_SUB
C$59 A GND 2.22360853131e-14 ; C_PO_SUB
C$60 B GND 1.30800501842e-15 ; C_PO_SUB
C$61 \$4 GND 1.30800501842e-15 ; C_PO_SUB
C$62 A GND 1.30800501842e-15 ; C_PO_SUB
C$63 A GND 1.96200752763e-14 ; C_PO_SUB
C$64 B GND 3.33541279697e-14 ; C_PO_SUB
C$65 \$4 GND 1.96200752763e-14 ; C_PO_SUB
C$66 A VDD 3.92401505526e-15 ; C_PO_NW
C$67 B VDD 6.5400250921e-15 ; C_PO_NW
C$68 A VDD 1.30800501842e-15 ; C_PO_NW
C$69 B VDD 3.92401505526e-15 ; C_PO_NW
C$70 \$4 VDD 3.92401505526e-15 ; C_PO_NW
C$71 B VDD 1.30800501842e-15 ; C_PO_NW
C$72 \$4 VDD 1.30800501842e-15 ; C_PO_NW
C$73 B VDD 3.27001254605e-15 ; C_PO_NW
C$74 A VDD 2.15820828039e-14 ; C_PO_NW
.ENDS XOR2X1
