* Extracted by KLayout (CIDESI_CM05, LNunT, CIDESI)

.SUBCKT XOR2X1 B Out A VDD GND
M$1 \$10 A VDD VDD CIDPMOS L=5U W=50U AS=625P AD=375P PS=125U PD=65U
M$2 VDD B \$10 VDD CIDPMOS L=5U W=50U AS=375P AD=625P PS=65U PD=125U
M$3 \$12 A VDD VDD CIDPMOS L=5U W=50U AS=625P AD=187.5P PS=125U PD=57.5U
M$4 \$4 B \$12 VDD CIDPMOS L=5U W=50U AS=187.5P AD=625P PS=57.5U PD=125U
M$5 Out \$4 \$10 VDD CIDPMOS L=5U W=50U AS=625P AD=625P PS=125U PD=125U
M$6 \$6 A GND GND CIDNMOS L=5U W=15U AS=187.5P AD=56.25P PS=55U PD=22.5U
M$7 Out B \$6 GND CIDNMOS L=5U W=15U AS=56.25P AD=187.5P PS=22.5U PD=55U
M$8 Out \$4 GND GND CIDNMOS L=5U W=10U AS=125P AD=125P PS=45U PD=45U
M$9 \$4 A GND GND CIDNMOS L=5U W=10U AS=125P AD=75P PS=45U PD=25U
M$10 GND B \$4 GND CIDNMOS L=5U W=10U AS=75P AD=125P PS=25U PD=45U
.ENDS XOR2X1
