* Extracted by KLayout (CIDESI_CM05, LNunT, CIDESI)

.SUBCKT Buffer_4X A Out VDD GND
M$1 VDD A \$4 VDD CIDPMOS L=5U W=25U AS=312.5P AD=187.5P PS=75U PD=40U
M$2 Out \$4 VDD VDD CIDPMOS L=5U W=25U AS=187.5P AD=187.5P PS=40U PD=40U
M$3 VDD \$4 Out VDD CIDPMOS L=5U W=25U AS=187.5P AD=187.5P PS=40U PD=40U
M$4 Out \$4 VDD VDD CIDPMOS L=5U W=25U AS=187.5P AD=187.5P PS=40U PD=40U
M$5 VDD \$4 Out VDD CIDPMOS L=5U W=25U AS=187.5P AD=312.5P PS=40U PD=75U
M$6 GND A \$4 GND CIDNMOS L=5U W=10U AS=125P AD=75P PS=45U PD=25U
M$7 Out \$4 GND GND CIDNMOS L=5U W=10U AS=75P AD=75P PS=25U PD=25U
M$8 GND \$4 Out GND CIDNMOS L=5U W=10U AS=75P AD=75P PS=25U PD=25U
M$9 Out \$4 GND GND CIDNMOS L=5U W=10U AS=75P AD=75P PS=25U PD=25U
M$10 GND \$4 Out GND CIDNMOS L=5U W=10U AS=75P AD=125P PS=25U PD=45U
.ENDS Buffer_4X
