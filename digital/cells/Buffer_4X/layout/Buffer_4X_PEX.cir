* Extracted by KLayout (CIDESI_CM05, LNunT, CIDESI)

.SUBCKT Buffer_4X A Out VDD GND
M$1 VDD A \$4 VDD CIDPMOS L=5U W=25U AS=312.5P AD=187.5P PS=75U PD=40U
M$2 Out \$4 VDD VDD CIDPMOS L=5U W=25U AS=187.5P AD=187.5P PS=40U PD=40U
M$3 VDD \$4 Out VDD CIDPMOS L=5U W=25U AS=187.5P AD=187.5P PS=40U PD=40U
M$4 Out \$4 VDD VDD CIDPMOS L=5U W=25U AS=187.5P AD=187.5P PS=40U PD=40U
M$5 VDD \$4 Out VDD CIDPMOS L=5U W=25U AS=187.5P AD=312.5P PS=40U PD=75U
M$6 GND A \$4 GND CIDNMOS L=5U W=10U AS=125P AD=75P PS=45U PD=25U
M$7 Out \$4 GND GND CIDNMOS L=5U W=10U AS=75P AD=75P PS=25U PD=25U
M$8 GND \$4 Out GND CIDNMOS L=5U W=10U AS=75P AD=75P PS=25U PD=25U
M$9 Out \$4 GND GND CIDNMOS L=5U W=10U AS=75P AD=75P PS=25U PD=25U
M$10 GND \$4 Out GND CIDNMOS L=5U W=10U AS=75P AD=125P PS=25U PD=45U
C$11 Out VDD 2.58984993647e-15 ; C_PAR_M1M2
C$12 A VDD 2.87761104052e-15 ; C_PAR_M1M2
C$13 Out GND 2.7337304885e-15 ; C_PAR_M1M2
C$14 A GND 2.7337304885e-15 ; C_PAR_M1M2
C$15 GND GND 3.0114534145e-15 ; C_M1_SUB
C$16 GND GND 3.0114534145e-15 ; C_M1_SUB
C$17 GND GND 1.8068720487e-14 ; C_M1_SUB
C$18 GND GND 1.8068720487e-14 ; C_M1_SUB
C$19 GND GND 1.8068720487e-14 ; C_M1_SUB
C$20 \$4 GND 4.51718012175e-15 ; C_M1_SUB
C$21 \$4 GND 7.27767908505e-15 ; C_M1_SUB
C$22 A GND 4.01527121934e-15 ; C_M1_SUB
C$23 Out GND 1.60610848773e-14 ; C_M1_SUB
C$24 Out GND 1.60610848773e-14 ; C_M1_SUB
C$25 \$4 VDD 7.02672463384e-15 ; C_M1_NW
C$26 \$4 VDD 4.01527121934e-15 ; C_M1_NW
C$27 Out VDD 9.03436024351e-15 ; C_M1_NW
C$28 Out VDD 9.03436024351e-15 ; C_M1_NW
C$29 VDD VDD 1.50572670725e-14 ; C_M1_NW
C$30 VDD VDD 1.50572670725e-14 ; C_M1_NW
C$31 VDD VDD 1.50572670725e-14 ; C_M1_NW
C$32 VDD VDD 3.0114534145e-15 ; C_M1_NW
C$33 VDD VDD 3.0114534145e-15 ; C_M1_NW
C$34 A GND 9.92279669147e-16 ; C_M2_SUB
C$35 Out GND 9.92279669147e-16 ; C_M2_SUB
C$36 A GND 1.67860644031e-14 ; C_M2_SUB
C$37 Out GND 3.96911867659e-15 ; C_M2_SUB
C$38 A GND 4.13449862144e-16 ; C_M2_SUB
C$39 Out GND 2.23262925558e-14 ; C_M2_SUB
C$40 A VDD 1.68687543755e-14 ; C_M2_NW
C$41 Out VDD 1.68687543755e-14 ; C_M2_NW
C$42 A VDD 9.92279669147e-16 ; C_M2_NW
C$43 Out VDD 9.92279669147e-16 ; C_M2_NW
C$44 A GND 1.30800501842e-15 ; C_PO_SUB
C$45 \$4 GND 7.84803011052e-15 ; C_PO_SUB
C$46 \$4 GND 7.84803011052e-15 ; C_PO_SUB
C$47 \$4 GND 1.30800501842e-15 ; C_PO_SUB
C$48 \$4 GND 7.84803011052e-15 ; C_PO_SUB
C$49 A GND 1.96200752763e-14 ; C_PO_SUB
C$50 \$4 GND 1.96200752763e-14 ; C_PO_SUB
C$51 A VDD 7.84803011052e-15 ; C_PO_NW
C$52 \$4 VDD 7.84803011052e-15 ; C_PO_NW
C$53 \$4 VDD 7.84803011052e-15 ; C_PO_NW
C$54 \$4 VDD 1.30800501842e-15 ; C_PO_NW
C$55 A VDD 1.30800501842e-15 ; C_PO_NW
C$56 \$4 VDD 7.84803011052e-15 ; C_PO_NW
C$57 \$4 VDD 7.84803011052e-15 ; C_PO_NW
.ENDS Buffer_4X
