* Extracted by KLayout (CIDESI_CM05, LNunT, CIDESI)

.SUBCKT Latch GBI GB G Data Q QB PRB VDD CLB GND
M$1 \$13 CLB VDD VDD CIDPMOS L=5U W=25U AS=312.5P AD=312.5P PS=75U PD=75U
M$2 \$25 \$6 Q VDD CIDPMOS L=5U W=25U AS=312.5P AD=125P PS=75U PD=35U
M$3 VDD \$13 \$25 VDD CIDPMOS L=5U W=25U AS=125P AD=187.5P PS=35U PD=40U
M$4 Q PRB VDD VDD CIDPMOS L=5U W=25U AS=187.5P AD=312.5P PS=40U PD=75U
M$5 \$21 GBI \$6 VDD CIDPMOS L=5U W=25U AS=312.5P AD=93.75P PS=75U PD=32.5U
M$6 VDD Data \$21 VDD CIDPMOS L=5U W=25U AS=93.75P AD=187.5P PS=32.5U PD=40U
M$7 QB Q VDD VDD CIDPMOS L=5U W=25U AS=187.5P AD=187.5P PS=40U PD=40U
M$8 \$6 G QB VDD CIDPMOS L=5U W=25U AS=187.5P AD=312.5P PS=40U PD=75U
M$9 VDD GB G VDD CIDPMOS L=5U W=25U AS=312.5P AD=187.5P PS=75U PD=40U
M$10 GBI G VDD VDD CIDPMOS L=5U W=25U AS=187.5P AD=312.5P PS=40U PD=75U
M$11 GND CLB \$13 GND CIDNMOS L=5U W=10U AS=125P AD=125P PS=45U PD=45U
M$12 \$11 \$13 Q GND CIDNMOS L=5U W=10U AS=125P AD=125P PS=45U PD=45U
M$13 \$11 \$6 Q GND CIDNMOS L=5U W=10U AS=125P AD=75P PS=45U PD=25U
M$14 GND PRB \$11 GND CIDNMOS L=5U W=10U AS=75P AD=125P PS=25U PD=45U
M$15 \$15 G \$6 GND CIDNMOS L=5U W=10U AS=125P AD=37.5P PS=45U PD=17.5U
M$16 GND Data \$15 GND CIDNMOS L=5U W=10U AS=37.5P AD=75P PS=17.5U PD=25U
M$17 QB Q GND GND CIDNMOS L=5U W=10U AS=75P AD=75P PS=25U PD=25U
M$18 \$6 GBI QB GND CIDNMOS L=5U W=10U AS=75P AD=125P PS=25U PD=45U
M$19 GND GB G GND CIDNMOS L=5U W=10U AS=125P AD=75P PS=45U PD=25U
M$20 GBI G GND GND CIDNMOS L=5U W=10U AS=75P AD=125P PS=25U PD=45U
C$21 CLB VDD 2.87761104052e-15 ; C_PAR_M1M2
C$22 PRB VDD 2.87761104052e-15 ; C_PAR_M1M2
C$23 Data VDD 2.87761104052e-15 ; C_PAR_M1M2
C$24 GB VDD 2.87761104052e-15 ; C_PAR_M1M2
C$25 PRB \$13 3.59701380066e-14 ; C_PAR_M1M2
C$26 Data G 1.6690144035e-14 ; C_PAR_M1M2
C$27 GB GND 2.87761104052e-15 ; C_PAR_M1M2
C$28 PRB GND 2.87761104052e-15 ; C_PAR_M1M2
C$29 Q QB 1.72656662432e-15 ; C_PAR_M1M2
C$30 Data GND 2.87761104052e-15 ; C_PAR_M1M2
C$31 \$11 Q 2.30208883242e-15 ; C_PAR_M1M2
C$32 CLB GND 4.60417766484e-15 ; C_PAR_M1M2
C$33 \$6 QB 1.72656662432e-15 ; C_PAR_M1M2
C$34 \$6 Q 2.30208883242e-15 ; C_PAR_M1M2
C$35 Data GB 5.75522208105e-16 ; C_PAR_M1M2
C$36 Data GBI 1.72656662432e-15 ; C_PAR_M1M2
C$37 Data \$6 2.30208883242e-15 ; C_PAR_M1M2
C$38 Q \$6 2.30208883242e-15 ; C_PAR_M1M2
C$39 Data GBI 2.30208883242e-15 ; C_PAR_M1M2
C$40 PRB Q 2.30208883242e-15 ; C_PAR_M1M2
C$41 GND GND 3.0114534145e-15 ; C_M1_SUB
C$42 GND GND 3.0114534145e-15 ; C_M1_SUB
C$43 GND GND 1.00381780483e-15 ; C_M1_SUB
C$44 GND GND 8.03054243867e-15 ; C_M1_SUB
C$45 GND GND 5.01908902417e-15 ; C_M1_SUB
C$46 GND GND 8.03054243867e-15 ; C_M1_SUB
C$47 GND GND 8.03054243867e-15 ; C_M1_SUB
C$48 G GND 4.01527121934e-15 ; C_M1_SUB
C$49 GBI GND 3.0114534145e-15 ; C_M1_SUB
C$50 GBI GND 3.0114534145e-15 ; C_M1_SUB
C$51 \$6 GND 4.01527121934e-15 ; C_M1_SUB
C$52 \$11 GND 5.01908902417e-15 ; C_M1_SUB
C$53 \$11 GND 5.01908902417e-15 ; C_M1_SUB
C$54 GB GND 4.01527121934e-15 ; C_M1_SUB
C$55 Q GND 6.52481573142e-15 ; C_M1_SUB
C$56 Data GND 4.01527121934e-15 ; C_M1_SUB
C$57 PRB GND 4.01527121934e-15 ; C_M1_SUB
C$58 CLB GND 4.01527121934e-15 ; C_M1_SUB
C$59 G GND 2.66011718281e-14 ; C_M1_SUB
C$60 G GND 1.50572670725e-15 ; C_M1_SUB
C$61 GBI GND 4.86851635345e-14 ; C_M1_SUB
C$62 \$6 GND 2.60992629257e-14 ; C_M1_SUB
C$63 QB GND 2.4091627316e-14 ; C_M1_SUB
C$64 \$6 GND 3.21221697547e-14 ; C_M1_SUB
C$65 Q GND 3.11183519499e-14 ; C_M1_SUB
C$66 \$6 GND 1.00381780483e-15 ; C_M1_SUB
C$67 Q GND 3.11183519499e-14 ; C_M1_SUB
C$68 \$13 GND 3.43807598156e-14 ; C_M1_SUB
C$69 G VDD 1.50572670725e-15 ; C_M1_NW
C$70 GBI VDD 4.01527121934e-15 ; C_M1_NW
C$71 \$6 VDD 3.0114534145e-15 ; C_M1_NW
C$72 \$6 VDD 6.02290682901e-15 ; C_M1_NW
C$73 \$13 VDD 8.03054243867e-15 ; C_M1_NW
C$74 G VDD 1.15439047556e-14 ; C_M1_NW
C$75 GBI VDD 8.28149688988e-15 ; C_M1_NW
C$76 \$6 VDD 2.00763560967e-15 ; C_M1_NW
C$77 QB VDD 8.28149688988e-15 ; C_M1_NW
C$78 \$6 VDD 1.00381780483e-14 ; C_M1_NW
C$79 Q VDD 1.10419958532e-14 ; C_M1_NW
C$80 \$13 VDD 1.00381780483e-15 ; C_M1_NW
C$81 Q VDD 1.35515403653e-14 ; C_M1_NW
C$82 VDD VDD 5.01908902417e-15 ; C_M1_NW
C$83 VDD VDD 5.01908902417e-15 ; C_M1_NW
C$84 VDD VDD 8.03054243867e-15 ; C_M1_NW
C$85 VDD VDD 1.00381780483e-15 ; C_M1_NW
C$86 VDD VDD 1.00381780483e-15 ; C_M1_NW
C$87 VDD VDD 8.03054243867e-15 ; C_M1_NW
C$88 VDD VDD 3.0114534145e-15 ; C_M1_NW
C$89 VDD VDD 3.0114534145e-15 ; C_M1_NW
C$90 GB GND 9.92279669147e-16 ; C_M2_SUB
C$91 Data GND 9.92279669147e-16 ; C_M2_SUB
C$92 PRB GND 9.92279669147e-16 ; C_M2_SUB
C$93 CLB GND 9.92279669147e-16 ; C_M2_SUB
C$94 PRB GND 3.80373873173e-15 ; C_M2_SUB
C$95 Data GND 6.28443790459e-15 ; C_M2_SUB
C$96 \$11 GND 1.32303955886e-15 ; C_M2_SUB
C$97 \$11 GND 6.61519779431e-16 ; C_M2_SUB
C$98 \$11 GND 3.30759889716e-16 ; C_M2_SUB
C$99 \$11 GND 3.30759889716e-16 ; C_M2_SUB
C$100 Q GND 3.30759889716e-16 ; C_M2_SUB
C$101 Q GND 6.61519779431e-16 ; C_M2_SUB
C$102 Q GND 1.32303955886e-15 ; C_M2_SUB
C$103 Q GND 9.92279669147e-16 ; C_M2_SUB
C$104 Q GND 3.30759889716e-16 ; C_M2_SUB
C$105 Q GND 3.96911867659e-15 ; C_M2_SUB
C$106 Q GND 6.61519779431e-16 ; C_M2_SUB
C$107 PRB GND 2.48069917287e-16 ; C_M2_SUB
C$108 Data GND 3.30759889716e-16 ; C_M2_SUB
C$109 Data GND 1.98455933829e-15 ; C_M2_SUB
C$110 Data GND 6.61519779431e-16 ; C_M2_SUB
C$111 Data GND 1.32303955886e-15 ; C_M2_SUB
C$112 Data GND 1.65379944858e-15 ; C_M2_SUB
C$113 Data GND 6.61519779431e-16 ; C_M2_SUB
C$114 PRB GND 6.61519779431e-16 ; C_M2_SUB
C$115 PRB GND 3.30759889716e-16 ; C_M2_SUB
C$116 CLB GND 1.62899245685e-14 ; C_M2_SUB
C$117 GB GND 2.01763532726e-14 ; C_M2_SUB
C$118 Data GND 8.26899724289e-15 ; C_M2_SUB
C$119 PRB GND 2.64607911772e-15 ; C_M2_SUB
C$120 CLB GND 2.39800920044e-15 ; C_M2_SUB
C$121 \$6 VDD 1.98455933829e-15 ; C_M2_NW
C$122 \$6 VDD 1.98455933829e-15 ; C_M2_NW
C$123 \$6 VDD 6.61519779431e-16 ; C_M2_NW
C$124 \$6 VDD 1.32303955886e-15 ; C_M2_NW
C$125 \$6 VDD 9.92279669147e-16 ; C_M2_NW
C$126 \$6 VDD 3.30759889716e-16 ; C_M2_NW
C$127 \$6 VDD 3.30759889716e-16 ; C_M2_NW
C$128 PRB VDD 6.61519779431e-16 ; C_M2_NW
C$129 GB VDD 1.43880552026e-14 ; C_M2_NW
C$130 Data VDD 1.09150763606e-14 ; C_M2_NW
C$131 PRB VDD 4.96139834573e-15 ; C_M2_NW
C$132 CLB VDD 1.43880552026e-14 ; C_M2_NW
C$133 GB VDD 9.92279669147e-16 ; C_M2_NW
C$134 Data VDD 9.92279669147e-16 ; C_M2_NW
C$135 PRB VDD 9.92279669147e-16 ; C_M2_NW
C$136 CLB VDD 9.92279669147e-16 ; C_M2_NW
C$137 GB GND 1.30800501842e-15 ; C_PO_SUB
C$138 G GND 1.30800501842e-15 ; C_PO_SUB
C$139 G GND 1.30800501842e-15 ; C_PO_SUB
C$140 Data GND 1.30800501842e-15 ; C_PO_SUB
C$141 Q GND 1.30800501842e-15 ; C_PO_SUB
C$142 \$6 GND 1.30800501842e-15 ; C_PO_SUB
C$143 PRB GND 1.30800501842e-15 ; C_PO_SUB
C$144 \$13 GND 1.30800501842e-15 ; C_PO_SUB
C$145 CLB GND 1.30800501842e-15 ; C_PO_SUB
C$146 GBI GND 3.98941530618e-14 ; C_PO_SUB
C$147 GBI GND 1.30800501842e-15 ; C_PO_SUB
C$148 GB GND 3.59701380066e-14 ; C_PO_SUB
C$149 G GND 4.21831618441e-14 ; C_PO_SUB
C$150 Data GND 2.74681053868e-14 ; C_PO_SUB
C$151 Q GND 2.55060978592e-14 ; C_PO_SUB
C$152 \$6 GND 2.94301129145e-14 ; C_PO_SUB
C$153 PRB GND 3.13921204421e-14 ; C_PO_SUB
C$154 \$13 GND 2.94301129145e-14 ; C_PO_SUB
C$155 CLB GND 2.94301129145e-14 ; C_PO_SUB
C$156 GB VDD 7.19402760131e-15 ; C_PO_NW
C$157 G VDD 9.48303638355e-15 ; C_PO_NW
C$158 GBI VDD 1.89660727671e-14 ; C_PO_NW
C$159 Data VDD 7.19402760131e-15 ; C_PO_NW
C$160 Q VDD 7.19402760131e-15 ; C_PO_NW
C$161 G VDD 1.30800501842e-15 ; C_PO_NW
C$162 \$6 VDD 7.19402760131e-15 ; C_PO_NW
C$163 \$13 VDD 1.30800501842e-15 ; C_PO_NW
C$164 PRB VDD 7.19402760131e-15 ; C_PO_NW
C$165 CLB VDD 1.17720451658e-14 ; C_PO_NW
C$166 GB VDD 1.30800501842e-15 ; C_PO_NW
C$167 GBI VDD 1.30800501842e-15 ; C_PO_NW
C$168 Data VDD 1.30800501842e-15 ; C_PO_NW
C$169 Q VDD 1.30800501842e-15 ; C_PO_NW
C$170 \$6 VDD 1.30800501842e-15 ; C_PO_NW
C$171 PRB VDD 1.30800501842e-15 ; C_PO_NW
C$172 CLB VDD 1.30800501842e-15 ; C_PO_NW
C$173 G VDD 3.79321455342e-14 ; C_PO_NW
C$174 \$13 VDD 3.27001254605e-14 ; C_PO_NW
.ENDS Latch
