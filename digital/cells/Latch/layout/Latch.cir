* Extracted by KLayout (CIDESI_CM05, LNunT, CIDESI)

.SUBCKT Latch GBI GB G Data Q QB PRB VDD CLB GND
M$1 \$13 CLB VDD VDD CIDPMOS L=5U W=25U AS=312.5P AD=312.5P PS=75U PD=75U
M$2 \$25 \$6 Q VDD CIDPMOS L=5U W=25U AS=312.5P AD=125P PS=75U PD=35U
M$3 VDD \$13 \$25 VDD CIDPMOS L=5U W=25U AS=125P AD=187.5P PS=35U PD=40U
M$4 Q PRB VDD VDD CIDPMOS L=5U W=25U AS=187.5P AD=312.5P PS=40U PD=75U
M$5 \$21 GBI \$6 VDD CIDPMOS L=5U W=25U AS=312.5P AD=93.75P PS=75U PD=32.5U
M$6 VDD Data \$21 VDD CIDPMOS L=5U W=25U AS=93.75P AD=187.5P PS=32.5U PD=40U
M$7 QB Q VDD VDD CIDPMOS L=5U W=25U AS=187.5P AD=187.5P PS=40U PD=40U
M$8 \$6 G QB VDD CIDPMOS L=5U W=25U AS=187.5P AD=312.5P PS=40U PD=75U
M$9 VDD GB G VDD CIDPMOS L=5U W=25U AS=312.5P AD=187.5P PS=75U PD=40U
M$10 GBI G VDD VDD CIDPMOS L=5U W=25U AS=187.5P AD=312.5P PS=40U PD=75U
M$11 GND CLB \$13 GND CIDNMOS L=5U W=10U AS=125P AD=125P PS=45U PD=45U
M$12 \$11 \$13 Q GND CIDNMOS L=5U W=10U AS=125P AD=125P PS=45U PD=45U
M$13 \$11 \$6 Q GND CIDNMOS L=5U W=10U AS=125P AD=75P PS=45U PD=25U
M$14 GND PRB \$11 GND CIDNMOS L=5U W=10U AS=75P AD=125P PS=25U PD=45U
M$15 \$15 G \$6 GND CIDNMOS L=5U W=10U AS=125P AD=37.5P PS=45U PD=17.5U
M$16 GND Data \$15 GND CIDNMOS L=5U W=10U AS=37.5P AD=75P PS=17.5U PD=25U
M$17 QB Q GND GND CIDNMOS L=5U W=10U AS=75P AD=75P PS=25U PD=25U
M$18 \$6 GBI QB GND CIDNMOS L=5U W=10U AS=75P AD=125P PS=25U PD=45U
M$19 GND GB G GND CIDNMOS L=5U W=10U AS=125P AD=75P PS=45U PD=25U
M$20 GBI G GND GND CIDNMOS L=5U W=10U AS=75P AD=125P PS=25U PD=45U
.ENDS Latch
