* Extracted by KLayout (CIDESI_CM05, LNunT, CIDESI)

.SUBCKT TAP VDD GND
C$1 GND GND 3.0114534145e-15 ; C_M1_SUB
C$2 GND GND 3.0114534145e-15 ; C_M1_SUB
C$3 GND GND 4.06546210958e-14 ; C_M1_SUB
C$4 VDD VDD 4.06546210958e-14 ; C_M1_NW
C$5 VDD VDD 3.0114534145e-15 ; C_M1_NW
C$6 VDD VDD 3.0114534145e-15 ; C_M1_NW
.ENDS TAP
