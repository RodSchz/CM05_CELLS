* Extracted by KLayout (CIDESI_CM05, LNunT, CIDESI)

.SUBCKT AND2X1 A B Out VDD GND
M$1 Out \$3 VDD VDD CIDPMOS L=5U W=50U AS=625P AD=625P PS=125U PD=125U
M$2 \$3 A VDD VDD CIDPMOS L=5U W=50U AS=625P AD=375P PS=125U PD=65U
M$3 VDD B \$3 VDD CIDPMOS L=5U W=50U AS=375P AD=625P PS=65U PD=125U
M$4 Out \$3 GND GND CIDNMOS L=5U W=15U AS=187.5P AD=187.5P PS=55U PD=55U
M$5 \$7 A \$3 GND CIDNMOS L=5U W=15U AS=187.5P AD=56.25P PS=55U PD=22.5U
M$6 GND B \$7 GND CIDNMOS L=5U W=15U AS=56.25P AD=187.5P PS=22.5U PD=55U
.ENDS AND2X1
