* Extracted by KLayout (CIDESI_CM05, LNunT, CIDESI)

.SUBCKT AND2X1 A B VDD Out GND
M$1 Out \$2 VDD VDD CIDPMOS L=5U W=50U AS=625P AD=625P PS=125U PD=125U
M$2 \$2 A VDD VDD CIDPMOS L=5U W=50U AS=625P AD=375P PS=125U PD=65U
M$3 VDD B \$2 VDD CIDPMOS L=5U W=50U AS=375P AD=625P PS=65U PD=125U
M$4 Out \$2 GND GND CIDNMOS L=5U W=15U AS=187.5P AD=187.5P PS=55U PD=55U
M$5 \$7 A \$2 GND CIDNMOS L=5U W=15U AS=187.5P AD=56.25P PS=55U PD=22.5U
M$6 GND B \$7 GND CIDNMOS L=5U W=15U AS=56.25P AD=187.5P PS=22.5U PD=55U
C$7 B VDD 5.85799390393e-15 ; C_PAR_M1M2
C$8 A VDD 6.16630937255e-15 ; C_PAR_M1M2
C$9 B \$2 7.39957124706e-15 ; C_PAR_M1M2
C$10 B GND 5.85799390393e-15 ; C_PAR_M1M2
C$11 Out VDD 5.85799390393e-15 ; C_PAR_M1M2
C$12 Out GND 5.85799390393e-15 ; C_PAR_M1M2
C$13 A GND 6.16630937255e-15 ; C_PAR_M1M2
C$14 GND GND 2.30208883242e-14 ; C_M1_SUB
C$15 GND GND 2.30208883242e-14 ; C_M1_SUB
C$16 Out GND 1.36686524425e-14 ; C_M1_SUB
C$17 B GND 7.19402760131e-15 ; C_M1_SUB
C$18 A GND 8.63283312158e-15 ; C_M1_SUB
C$19 \$2 GND 2.12223814239e-14 ; C_M1_SUB
C$20 \$2 GND 5.03581932092e-15 ; C_M1_SUB
C$21 \$2 VDD 1.51074579628e-14 ; C_M1_NW
C$22 \$2 VDD 9.71193726177e-15 ; C_M1_NW
C$23 Out VDD 1.36686524425e-14 ; C_M1_NW
C$24 VDD VDD 1.29492496824e-14 ; C_M1_NW
C$25 VDD VDD 1.29492496824e-14 ; C_M1_NW
C$26 VDD VDD 1.29492496824e-14 ; C_M1_NW
C$27 A GND 1.67087092676e-15 ; C_M2_SUB
C$28 B GND 1.67087092676e-15 ; C_M2_SUB
C$29 Out GND 1.67087092676e-15 ; C_M2_SUB
C$30 Out GND 1.33669674141e-14 ; C_M2_SUB
C$31 B GND 2.81263272671e-14 ; C_M2_SUB
C$32 A GND 2.89617627304e-14 ; C_M2_SUB
C$33 Out GND 1.33669674141e-14 ; C_M2_SUB
C$34 Out VDD 5.01261278027e-15 ; C_M2_NW
C$35 A VDD 2.92402412182e-14 ; C_M2_NW
C$36 B VDD 2.67339348281e-14 ; C_M2_NW
C$37 Out VDD 1.92150156577e-14 ; C_M2_NW
C$38 A VDD 1.67087092676e-15 ; C_M2_NW
C$39 B VDD 1.67087092676e-15 ; C_M2_NW
C$40 Out VDD 1.67087092676e-15 ; C_M2_NW
C$41 A GND 2.15820828039e-15 ; C_PO_SUB
C$42 B GND 2.15820828039e-15 ; C_PO_SUB
C$43 \$2 GND 2.15820828039e-15 ; C_PO_SUB
C$44 A GND 3.18335721358e-14 ; C_PO_SUB
C$45 B GND 3.12940200657e-14 ; C_PO_SUB
C$46 \$2 GND 2.15820828039e-14 ; C_PO_SUB
C$47 A VDD 9.17238519167e-15 ; C_PO_NW
C$48 B VDD 6.47462484118e-15 ; C_PO_NW
C$49 \$2 VDD 1.29492496824e-14 ; C_PO_NW
C$50 A VDD 2.15820828039e-15 ; C_PO_NW
C$51 B VDD 2.15820828039e-15 ; C_PO_NW
C$52 \$2 VDD 2.15820828039e-15 ; C_PO_NW
.ENDS AND2X1
