* Extracted by KLayout (CIDESI_CM05, LNunT, CIDESI)

.SUBCKT AND2X1 A B Out VDD GND
M$1 Out \$3 VDD VDD CIDPMOS L=5U W=50U AS=625P AD=625P PS=125U PD=125U
M$2 \$3 A VDD VDD CIDPMOS L=5U W=50U AS=625P AD=375P PS=125U PD=65U
M$3 VDD B \$3 VDD CIDPMOS L=5U W=50U AS=375P AD=625P PS=65U PD=125U
M$4 Out \$3 GND GND CIDNMOS L=5U W=15U AS=187.5P AD=187.5P PS=55U PD=55U
M$5 \$7 A \$3 GND CIDNMOS L=5U W=15U AS=187.5P AD=56.25P PS=55U PD=22.5U
M$6 GND B \$7 GND CIDNMOS L=5U W=15U AS=56.25P AD=187.5P PS=22.5U PD=55U
C$7 B VDD 2.7337304885e-15 ; C_PAR_M1M2
C$8 A VDD 2.87761104052e-15 ; C_PAR_M1M2
C$9 B \$3 3.45313324863e-15 ; C_PAR_M1M2
C$10 B GND 2.7337304885e-15 ; C_PAR_M1M2
C$11 Out VDD 2.7337304885e-15 ; C_PAR_M1M2
C$12 Out GND 2.7337304885e-15 ; C_PAR_M1M2
C$13 A GND 2.87761104052e-15 ; C_PAR_M1M2
C$14 GND GND 3.0114534145e-15 ; C_M1_SUB
C$15 GND GND 3.0114534145e-15 ; C_M1_SUB
C$16 GND GND 1.60610848773e-14 ; C_M1_SUB
C$17 GND GND 1.60610848773e-14 ; C_M1_SUB
C$18 Out GND 9.53626914593e-15 ; C_M1_SUB
C$19 B GND 5.01908902417e-15 ; C_M1_SUB
C$20 A GND 6.02290682901e-15 ; C_M1_SUB
C$21 \$3 GND 1.48063126213e-14 ; C_M1_SUB
C$22 \$3 GND 3.51336231692e-15 ; C_M1_SUB
C$23 \$3 VDD 1.05400869508e-14 ; C_M1_NW
C$24 \$3 VDD 6.77577018263e-15 ; C_M1_NW
C$25 Out VDD 9.53626914593e-15 ; C_M1_NW
C$26 VDD VDD 9.03436024351e-15 ; C_M1_NW
C$27 VDD VDD 9.03436024351e-15 ; C_M1_NW
C$28 VDD VDD 9.03436024351e-15 ; C_M1_NW
C$29 VDD VDD 3.0114534145e-15 ; C_M1_NW
C$30 VDD VDD 3.0114534145e-15 ; C_M1_NW
C$31 A GND 9.92279669147e-16 ; C_M2_SUB
C$32 B GND 9.92279669147e-16 ; C_M2_SUB
C$33 Out GND 9.92279669147e-16 ; C_M2_SUB
C$34 Out GND 7.93823735317e-15 ; C_M2_SUB
C$35 B GND 1.67033744306e-14 ; C_M2_SUB
C$36 A GND 1.71995142652e-14 ; C_M2_SUB
C$37 Out GND 7.93823735317e-15 ; C_M2_SUB
C$38 Out VDD 2.97683900744e-15 ; C_M2_NW
C$39 A VDD 1.73648942101e-14 ; C_M2_NW
C$40 B VDD 1.58764747063e-14 ; C_M2_NW
C$41 Out VDD 1.14112161952e-14 ; C_M2_NW
C$42 A VDD 9.92279669147e-16 ; C_M2_NW
C$43 B VDD 9.92279669147e-16 ; C_M2_NW
C$44 Out VDD 9.92279669147e-16 ; C_M2_NW
C$45 A GND 1.30800501842e-15 ; C_PO_SUB
C$46 B GND 1.30800501842e-15 ; C_PO_SUB
C$47 \$3 GND 1.30800501842e-15 ; C_PO_SUB
C$48 A GND 1.92930740217e-14 ; C_PO_SUB
C$49 B GND 1.89660727671e-14 ; C_PO_SUB
C$50 \$3 GND 1.30800501842e-14 ; C_PO_SUB
C$51 A VDD 5.55902132829e-15 ; C_PO_NW
C$52 B VDD 3.92401505526e-15 ; C_PO_NW
C$53 \$3 VDD 7.84803011052e-15 ; C_PO_NW
C$54 A VDD 1.30800501842e-15 ; C_PO_NW
C$55 B VDD 1.30800501842e-15 ; C_PO_NW
C$56 \$3 VDD 1.30800501842e-15 ; C_PO_NW
.ENDS AND2X1
