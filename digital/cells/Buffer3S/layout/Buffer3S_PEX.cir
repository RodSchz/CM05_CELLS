* Extracted by KLayout (CIDESI_CM05, LNunT, CIDESI)

.SUBCKT Buffer3S OEB Data Out VDD GND
M$1 VDD Data \$6 VDD CIDPMOS L=5U W=25U AS=312.5P AD=187.5P PS=75U PD=40U
M$2 Out \$6 VDD VDD CIDPMOS L=5U W=25U AS=187.5P AD=312.5P PS=40U PD=75U
M$3 VDD OEB \$5 VDD CIDPMOS L=5U W=25U AS=312.5P AD=187.5P PS=75U PD=40U
M$4 \$6 \$5 VDD VDD CIDPMOS L=5U W=25U AS=187.5P AD=187.5P PS=40U PD=40U
M$5 \$3 OEB \$6 VDD CIDPMOS L=5U W=25U AS=187.5P AD=312.5P PS=40U PD=75U
M$6 GND Data \$3 GND CIDNMOS L=5U W=10U AS=125P AD=75P PS=45U PD=25U
M$7 Out \$3 GND GND CIDNMOS L=5U W=10U AS=75P AD=125P PS=25U PD=45U
M$8 GND OEB \$5 GND CIDNMOS L=5U W=10U AS=125P AD=75P PS=45U PD=25U
M$9 \$3 OEB GND GND CIDNMOS L=5U W=10U AS=75P AD=75P PS=25U PD=25U
M$10 \$6 \$5 \$3 GND CIDNMOS L=5U W=10U AS=75P AD=125P PS=25U PD=45U
C$11 OEB VDD 2.87761104052e-15 ; C_PAR_M1M2
C$12 Data VDD 1.41002940986e-14 ; C_PAR_M1M2
C$13 \$6 \$3 6.33074428916e-15 ; C_PAR_M1M2
C$14 \$3 Data 8.63283312158e-16 ; C_PAR_M1M2
C$15 \$3 \$6 2.30208883242e-15 ; C_PAR_M1M2
C$16 Data GND 1.1222683058e-14 ; C_PAR_M1M2
C$17 Out VDD 2.87761104052e-15 ; C_PAR_M1M2
C$18 Out GND 2.87761104052e-15 ; C_PAR_M1M2
C$19 OEB GND 2.87761104052e-15 ; C_PAR_M1M2
C$20 GND GND 3.0114534145e-15 ; C_M1_SUB
C$21 GND GND 3.0114534145e-15 ; C_M1_SUB
C$22 \$3 GND 1.00381780483e-15 ; C_M1_SUB
C$23 GND GND 5.01908902417e-15 ; C_M1_SUB
C$24 GND GND 1.2045813658e-14 ; C_M1_SUB
C$25 \$3 GND 4.51718012175e-15 ; C_M1_SUB
C$26 GND GND 5.01908902417e-15 ; C_M1_SUB
C$27 \$3 GND 4.01527121934e-15 ; C_M1_SUB
C$28 \$3 GND 4.01527121934e-15 ; C_M1_SUB
C$29 \$5 GND 7.02672463384e-15 ; C_M1_SUB
C$30 \$6 GND 1.10419958532e-14 ; C_M1_SUB
C$31 OEB GND 5.01908902417e-15 ; C_M1_SUB
C$32 Data GND 4.01527121934e-15 ; C_M1_SUB
C$33 \$5 GND 1.48063126213e-14 ; C_M1_SUB
C$34 \$5 GND 2.25859006088e-15 ; C_M1_SUB
C$35 Out GND 2.20839917064e-14 ; C_M1_SUB
C$36 \$5 VDD 7.52863353626e-16 ; C_M1_NW
C$37 \$5 VDD 1.22967681092e-14 ; C_M1_NW
C$38 \$6 VDD 4.01527121934e-15 ; C_M1_NW
C$39 \$3 VDD 1.90725382919e-14 ; C_M1_NW
C$40 \$6 VDD 4.01527121934e-15 ; C_M1_NW
C$41 Out VDD 1.2045813658e-14 ; C_M1_NW
C$42 VDD VDD 5.01908902417e-15 ; C_M1_NW
C$43 \$6 VDD 7.02672463384e-15 ; C_M1_NW
C$44 VDD VDD 8.03054243867e-15 ; C_M1_NW
C$45 VDD VDD 5.01908902417e-15 ; C_M1_NW
C$46 VDD VDD 2.00763560967e-15 ; C_M1_NW
C$47 VDD VDD 3.0114534145e-15 ; C_M1_NW
C$48 VDD VDD 3.0114534145e-15 ; C_M1_NW
C$49 OEB GND 9.92279669147e-16 ; C_M2_SUB
C$50 Data GND 9.92279669147e-16 ; C_M2_SUB
C$51 Out GND 9.92279669147e-16 ; C_M2_SUB
C$52 Data GND 4.13449862144e-16 ; C_M2_SUB
C$53 Data GND 4.13449862144e-16 ; C_M2_SUB
C$54 Data GND 4.13449862144e-16 ; C_M2_SUB
C$55 Data GND 4.13449862144e-16 ; C_M2_SUB
C$56 \$3 GND 3.30759889716e-16 ; C_M2_SUB
C$57 \$3 GND 3.30759889716e-16 ; C_M2_SUB
C$58 OEB GND 1.48841950372e-14 ; C_M2_SUB
C$59 \$6 GND 3.63835878687e-15 ; C_M2_SUB
C$60 \$3 GND 5.78829807002e-15 ; C_M2_SUB
C$61 Data GND 9.75741674661e-15 ; C_M2_SUB
C$62 Out GND 1.96802134381e-14 ; C_M2_SUB
C$63 \$6 VDD 1.157659614e-15 ; C_M2_NW
C$64 \$6 VDD 1.32303955886e-15 ; C_M2_NW
C$65 Data VDD 5.95367801488e-15 ; C_M2_NW
C$66 Data VDD 6.61519779431e-16 ; C_M2_NW
C$67 Data VDD 6.61519779431e-16 ; C_M2_NW
C$68 OEB VDD 1.68687543755e-14 ; C_M2_NW
C$69 Data VDD 1.65379944858e-16 ; C_M2_NW
C$70 Data VDD 1.65379944858e-16 ; C_M2_NW
C$71 Out VDD 1.68687543755e-14 ; C_M2_NW
C$72 OEB VDD 9.92279669147e-16 ; C_M2_NW
C$73 Data VDD 9.92279669147e-16 ; C_M2_NW
C$74 Out VDD 9.92279669147e-16 ; C_M2_NW
C$75 OEB GND 1.30800501842e-15 ; C_PO_SUB
C$76 OEB GND 1.30800501842e-15 ; C_PO_SUB
C$77 \$5 GND 1.30800501842e-15 ; C_PO_SUB
C$78 Data GND 1.30800501842e-15 ; C_PO_SUB
C$79 \$3 GND 2.22360853131e-14 ; C_PO_SUB
C$80 \$3 GND 1.30800501842e-15 ; C_PO_SUB
C$81 OEB GND 3.59701380066e-14 ; C_PO_SUB
C$82 \$5 GND 2.35440903316e-14 ; C_PO_SUB
C$83 Data GND 2.15820828039e-14 ; C_PO_SUB
C$84 OEB VDD 7.84803011052e-15 ; C_PO_NW
C$85 \$5 VDD 1.04640401474e-14 ; C_PO_NW
C$86 OEB VDD 1.30800501842e-15 ; C_PO_NW
C$87 Data VDD 7.84803011052e-15 ; C_PO_NW
C$88 \$6 VDD 1.30800501842e-15 ; C_PO_NW
C$89 \$5 VDD 1.30800501842e-15 ; C_PO_NW
C$90 Data VDD 1.30800501842e-15 ; C_PO_NW
C$91 OEB VDD 1.83120702579e-14 ; C_PO_NW
C$92 \$6 VDD 2.485209535e-14 ; C_PO_NW
.ENDS Buffer3S
