* Extracted by KLayout (CIDESI_CM05, LNunT, CIDESI)

.SUBCKT Buffer3S OEB Data Out VDD GND
M$1 VDD Data \$6 VDD CIDPMOS L=5U W=25U AS=312.5P AD=187.5P PS=75U PD=40U
M$2 Out \$6 VDD VDD CIDPMOS L=5U W=25U AS=187.5P AD=312.5P PS=40U PD=75U
M$3 VDD OEB \$5 VDD CIDPMOS L=5U W=25U AS=312.5P AD=187.5P PS=75U PD=40U
M$4 \$6 \$5 VDD VDD CIDPMOS L=5U W=25U AS=187.5P AD=187.5P PS=40U PD=40U
M$5 \$3 OEB \$6 VDD CIDPMOS L=5U W=25U AS=187.5P AD=312.5P PS=40U PD=75U
M$6 GND Data \$3 GND CIDNMOS L=5U W=10U AS=125P AD=75P PS=45U PD=25U
M$7 Out \$3 GND GND CIDNMOS L=5U W=10U AS=75P AD=125P PS=25U PD=45U
M$8 GND OEB \$5 GND CIDNMOS L=5U W=10U AS=125P AD=75P PS=45U PD=25U
M$9 \$3 OEB GND GND CIDNMOS L=5U W=10U AS=75P AD=75P PS=25U PD=25U
M$10 \$6 \$5 \$3 GND CIDNMOS L=5U W=10U AS=75P AD=125P PS=25U PD=45U
.ENDS Buffer3S
