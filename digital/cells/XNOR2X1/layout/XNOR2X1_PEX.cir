* Extracted by KLayout (CIDESI_CM05, LNunT, CIDESI)

.SUBCKT XNOR2X1 B A Out VDD GND
M$1 \$14 A VDD VDD CIDPMOS L=5U W=50U AS=625P AD=187.5P PS=125U PD=57.5U
M$2 Out B \$14 VDD CIDPMOS L=5U W=50U AS=187.5P AD=625P PS=57.5U PD=125U
M$3 Out \$5 VDD VDD CIDPMOS L=5U W=50U AS=625P AD=625P PS=125U PD=125U
M$4 \$5 B VDD VDD CIDPMOS L=5U W=50U AS=625P AD=375P PS=125U PD=65U
M$5 VDD A \$5 VDD CIDPMOS L=5U W=50U AS=375P AD=625P PS=65U PD=125U
M$6 \$9 B GND GND CIDNMOS L=5U W=20U AS=250P AD=75P PS=65U PD=27.5U
M$7 \$5 A \$9 GND CIDNMOS L=5U W=20U AS=75P AD=250P PS=27.5U PD=65U
M$8 Out \$5 \$7 GND CIDNMOS L=5U W=10U AS=125P AD=125P PS=45U PD=45U
M$9 \$7 A GND GND CIDNMOS L=5U W=10U AS=125P AD=75P PS=45U PD=25U
M$10 GND B \$7 GND CIDNMOS L=5U W=10U AS=75P AD=125P PS=25U PD=45U
C$11 Out VDD 2.87761104052e-15 ; C_PAR_M1M2
C$12 A VDD 2.58984993647e-15 ; C_PAR_M1M2
C$13 B Out 3.45313324863e-15 ; C_PAR_M1M2
C$14 B Out 3.45313324863e-15 ; C_PAR_M1M2
C$15 B VDD 2.87761104052e-15 ; C_PAR_M1M2
C$16 Out VDD 2.30208883242e-15 ; C_PAR_M1M2
C$17 Out GND 2.87761104052e-15 ; C_PAR_M1M2
C$18 B GND 2.87761104052e-15 ; C_PAR_M1M2
C$19 A \$5 3.45313324863e-15 ; C_PAR_M1M2
C$20 A GND 2.58984993647e-15 ; C_PAR_M1M2
C$21 GND GND 3.0114534145e-15 ; C_M1_SUB
C$22 GND GND 3.0114534145e-15 ; C_M1_SUB
C$23 GND GND 4.01527121934e-15 ; C_M1_SUB
C$24 GND GND 1.10419958532e-14 ; C_M1_SUB
C$25 GND GND 7.02672463384e-15 ; C_M1_SUB
C$26 GND GND 1.30496314628e-14 ; C_M1_SUB
C$27 \$5 GND 5.01908902417e-16 ; C_M1_SUB
C$28 \$7 GND 4.01527121934e-15 ; C_M1_SUB
C$29 \$7 GND 4.01527121934e-15 ; C_M1_SUB
C$30 A GND 4.01527121934e-15 ; C_M1_SUB
C$31 B GND 4.01527121934e-15 ; C_M1_SUB
C$32 \$5 GND 1.60610848773e-14 ; C_M1_SUB
C$33 \$5 GND 1.25477225604e-15 ; C_M1_SUB
C$34 Out GND 3.91488943885e-14 ; C_M1_SUB
C$35 \$5 VDD 2.76049896329e-15 ; C_M1_NW
C$36 \$5 VDD 5.01908902417e-15 ; C_M1_NW
C$37 Out VDD 6.02290682901e-15 ; C_M1_NW
C$38 VDD VDD 5.01908902417e-15 ; C_M1_NW
C$39 VDD VDD 5.01908902417e-15 ; C_M1_NW
C$40 Out VDD 4.01527121934e-15 ; C_M1_NW
C$41 Out VDD 4.01527121934e-15 ; C_M1_NW
C$42 VDD VDD 9.03436024351e-15 ; C_M1_NW
C$43 VDD VDD 2.00763560967e-15 ; C_M1_NW
C$44 VDD VDD 2.00763560967e-15 ; C_M1_NW
C$45 VDD VDD 9.03436024351e-15 ; C_M1_NW
C$46 VDD VDD 3.0114534145e-15 ; C_M1_NW
C$47 VDD VDD 3.0114534145e-15 ; C_M1_NW
C$48 A GND 9.92279669147e-16 ; C_M2_SUB
C$49 B GND 9.92279669147e-16 ; C_M2_SUB
C$50 Out GND 9.92279669147e-16 ; C_M2_SUB
C$51 \$7 GND 3.30759889716e-16 ; C_M2_SUB
C$52 \$7 GND 2.97683900744e-15 ; C_M2_SUB
C$53 A GND 2.81145906258e-15 ; C_M2_SUB
C$54 B GND 3.80373873173e-15 ; C_M2_SUB
C$55 B GND 4.96139834573e-16 ; C_M2_SUB
C$56 B GND 1.88533137138e-14 ; C_M2_SUB
C$57 A GND 2.38147120595e-14 ; C_M2_SUB
C$58 \$5 GND 1.07496964158e-15 ; C_M2_SUB
C$59 \$5 GND 5.78829807002e-16 ; C_M2_SUB
C$60 \$5 GND 2.48069917287e-16 ; C_M2_SUB
C$61 Out GND 1.71995142652e-14 ; C_M2_SUB
C$62 \$5 VDD 2.23262925558e-15 ; C_M2_NW
C$63 \$5 VDD 1.40572953129e-15 ; C_M2_NW
C$64 \$5 VDD 7.4420975186e-16 ; C_M2_NW
C$65 Out VDD 9.92279669147e-16 ; C_M2_NW
C$66 Out VDD 1.157659614e-15 ; C_M2_NW
C$67 A VDD 1.73648942101e-14 ; C_M2_NW
C$68 B VDD 1.73648942101e-14 ; C_M2_NW
C$69 Out VDD 1.73648942101e-14 ; C_M2_NW
C$70 A VDD 9.92279669147e-16 ; C_M2_NW
C$71 B VDD 9.92279669147e-16 ; C_M2_NW
C$72 Out VDD 9.92279669147e-16 ; C_M2_NW
C$73 A GND 1.30800501842e-15 ; C_PO_SUB
C$74 A GND 1.30800501842e-15 ; C_PO_SUB
C$75 B GND 2.8122107896e-14 ; C_PO_SUB
C$76 \$5 GND 1.30800501842e-15 ; C_PO_SUB
C$77 B GND 1.30800501842e-15 ; C_PO_SUB
C$78 A GND 3.20461229513e-14 ; C_PO_SUB
C$79 B GND 2.02740777855e-14 ; C_PO_SUB
C$80 \$5 GND 1.70040652395e-14 ; C_PO_SUB
C$81 B VDD 1.30800501842e-15 ; C_PO_NW
C$82 A VDD 1.5696060221e-14 ; C_PO_NW
C$83 B VDD 3.92401505526e-15 ; C_PO_NW
C$84 \$5 VDD 9.15603512894e-15 ; C_PO_NW
C$85 A VDD 1.30800501842e-15 ; C_PO_NW
C$86 A VDD 1.30800501842e-15 ; C_PO_NW
C$87 \$5 VDD 1.30800501842e-15 ; C_PO_NW
C$88 B VDD 2.68141028776e-14 ; C_PO_NW
.ENDS XNOR2X1
