* Extracted by KLayout (CIDESI_CM05, LNunT, CIDESI)

.SUBCKT XNOR2X1 B A Out VDD GND
M$1 \$14 A VDD VDD CIDPMOS L=5U W=50U AS=625P AD=187.5P PS=125U PD=57.5U
M$2 Out B \$14 VDD CIDPMOS L=5U W=50U AS=187.5P AD=625P PS=57.5U PD=125U
M$3 Out \$5 VDD VDD CIDPMOS L=5U W=50U AS=625P AD=625P PS=125U PD=125U
M$4 \$5 B VDD VDD CIDPMOS L=5U W=50U AS=625P AD=375P PS=125U PD=65U
M$5 VDD A \$5 VDD CIDPMOS L=5U W=50U AS=375P AD=625P PS=65U PD=125U
M$6 \$9 B GND GND CIDNMOS L=5U W=20U AS=250P AD=75P PS=65U PD=27.5U
M$7 \$5 A \$9 GND CIDNMOS L=5U W=20U AS=75P AD=250P PS=27.5U PD=65U
M$8 Out \$5 \$7 GND CIDNMOS L=5U W=10U AS=125P AD=125P PS=45U PD=45U
M$9 \$7 A GND GND CIDNMOS L=5U W=10U AS=125P AD=75P PS=45U PD=25U
M$10 GND B \$7 GND CIDNMOS L=5U W=10U AS=75P AD=125P PS=25U PD=45U
.ENDS XNOR2X1
