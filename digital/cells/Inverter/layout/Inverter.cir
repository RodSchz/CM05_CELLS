* Extracted by KLayout (CIDESI_CM05, LNunT, CIDESI)

.SUBCKT Inverter VDD A Out GND
M$1 Out A VDD VDD CIDPMOS L=5U W=25U AS=312.5P AD=312.5P PS=75U PD=75U
M$2 Out A GND GND CIDNMOS L=5U W=10U AS=125P AD=125P PS=45U PD=45U
.ENDS Inverter
