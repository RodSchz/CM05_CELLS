* Extracted by KLayout (CIDESI_CM05, LNunT, CIDESI)

.SUBCKT Inverter VDD A Out GND
M$1 Out A VDD VDD CIDPMOS L=5U W=25U AS=312.5P AD=312.5P PS=75U PD=75U
M$2 Out A GND GND CIDNMOS L=5U W=10U AS=125P AD=125P PS=45U PD=45U
C$3 Out VDD 2.58984993647e-15 ; C_PAR_M1M2
C$4 A VDD 2.58984993647e-15 ; C_PAR_M1M2
C$5 Out GND 2.58984993647e-15 ; C_PAR_M1M2
C$6 A GND 2.58984993647e-15 ; C_PAR_M1M2
C$7 GND GND 3.0114534145e-15 ; C_M1_SUB
C$8 GND GND 3.0114534145e-15 ; C_M1_SUB
C$9 GND GND 1.70649026822e-14 ; C_M1_SUB
C$10 Out GND 4.01527121934e-15 ; C_M1_SUB
C$11 A GND 4.01527121934e-15 ; C_M1_SUB
C$12 Out VDD 4.01527121934e-15 ; C_M1_NW
C$13 VDD VDD 9.03436024351e-15 ; C_M1_NW
C$14 VDD VDD 3.0114534145e-15 ; C_M1_NW
C$15 VDD VDD 3.0114534145e-15 ; C_M1_NW
C$16 A GND 9.92279669147e-16 ; C_M2_SUB
C$17 Out GND 9.92279669147e-16 ; C_M2_SUB
C$18 A GND 1.76956540998e-14 ; C_M2_SUB
C$19 Out GND 1.75302741549e-14 ; C_M2_SUB
C$20 A VDD 1.73648942101e-14 ; C_M2_NW
C$21 Out VDD 1.60418546512e-14 ; C_M2_NW
C$22 A VDD 9.92279669147e-16 ; C_M2_NW
C$23 Out VDD 9.92279669147e-16 ; C_M2_NW
C$24 A GND 1.30800501842e-15 ; C_PO_SUB
C$25 A GND 1.96200752763e-14 ; C_PO_SUB
C$26 A VDD 1.04640401474e-14 ; C_PO_NW
C$27 A VDD 1.30800501842e-15 ; C_PO_NW
.ENDS Inverter
