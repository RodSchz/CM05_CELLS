* Extracted by KLayout (CIDESI_CM05, LNunT, CIDESI)

.SUBCKT NAND2X1 Out B A VDD GND
M$1 Out A VDD VDD CIDPMOS L=5U W=50U AS=625P AD=375P PS=125U PD=65U
M$2 VDD B Out VDD CIDPMOS L=5U W=50U AS=375P AD=625P PS=65U PD=125U
M$3 \$6 A Out GND CIDNMOS L=5U W=15U AS=187.5P AD=56.25P PS=55U PD=22.5U
M$4 GND B \$6 GND CIDNMOS L=5U W=15U AS=56.25P AD=187.5P PS=22.5U PD=55U
C$5 B VDD 2.87761104052e-15 ; C_PAR_M1M2
C$6 Out VDD 2.58984993647e-15 ; C_PAR_M1M2
C$7 A VDD 2.87761104052e-15 ; C_PAR_M1M2
C$8 B GND 2.87761104052e-15 ; C_PAR_M1M2
C$9 Out GND 2.58984993647e-15 ; C_PAR_M1M2
C$10 A GND 2.87761104052e-15 ; C_PAR_M1M2
C$11 GND GND 3.0114534145e-15 ; C_M1_SUB
C$12 GND GND 3.0114534145e-15 ; C_M1_SUB
C$13 GND GND 1.60610848773e-14 ; C_M1_SUB
C$14 Out GND 2.50954451209e-16 ; C_M1_SUB
C$15 B GND 4.01527121934e-15 ; C_M1_SUB
C$16 A GND 1.25477225604e-15 ; C_M1_SUB
C$17 Out GND 1.27986770116e-14 ; C_M1_SUB
C$18 A VDD 2.76049896329e-15 ; C_M1_NW
C$19 Out VDD 6.02290682901e-15 ; C_M1_NW
C$20 VDD VDD 9.03436024351e-15 ; C_M1_NW
C$21 VDD VDD 9.03436024351e-15 ; C_M1_NW
C$22 VDD VDD 3.0114534145e-15 ; C_M1_NW
C$23 VDD VDD 3.0114534145e-15 ; C_M1_NW
C$24 A GND 9.92279669147e-16 ; C_M2_SUB
C$25 Out GND 9.92279669147e-16 ; C_M2_SUB
C$26 B GND 9.92279669147e-16 ; C_M2_SUB
C$27 Out GND 7.60747746346e-15 ; C_M2_SUB
C$28 Out GND 8.26899724289e-17 ; C_M2_SUB
C$29 A GND 1.84398638516e-14 ; C_M2_SUB
C$30 Out GND 1.07496964158e-15 ; C_M2_SUB
C$31 Out GND 1.32303955886e-15 ; C_M2_SUB
C$32 B GND 1.71995142652e-14 ; C_M2_SUB
C$33 Out VDD 4.96139834573e-16 ; C_M2_NW
C$34 Out VDD 4.96139834573e-16 ; C_M2_NW
C$35 A VDD 1.61245446236e-14 ; C_M2_NW
C$36 Out VDD 4.46525851116e-15 ; C_M2_NW
C$37 B VDD 1.73648942101e-14 ; C_M2_NW
C$38 A VDD 9.92279669147e-16 ; C_M2_NW
C$39 Out VDD 9.92279669147e-16 ; C_M2_NW
C$40 B VDD 9.92279669147e-16 ; C_M2_NW
C$41 A GND 1.30800501842e-15 ; C_PO_SUB
C$42 B GND 1.30800501842e-15 ; C_PO_SUB
C$43 A GND 1.70040652395e-14 ; C_PO_SUB
C$44 B GND 1.96200752763e-14 ; C_PO_SUB
C$45 A VDD 1.04640401474e-14 ; C_PO_NW
C$46 B VDD 3.92401505526e-15 ; C_PO_NW
C$47 A VDD 1.30800501842e-15 ; C_PO_NW
C$48 B VDD 1.30800501842e-15 ; C_PO_NW
.ENDS NAND2X1
