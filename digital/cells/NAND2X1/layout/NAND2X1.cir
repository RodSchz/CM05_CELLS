* Extracted by KLayout (CIDESI_CM05, LNunT, CIDESI)

.SUBCKT NAND2X1 Out B A VDD GND
M$1 Out A VDD VDD CIDPMOS L=5U W=50U AS=625P AD=375P PS=125U PD=65U
M$2 VDD B Out VDD CIDPMOS L=5U W=50U AS=375P AD=625P PS=65U PD=125U
M$3 \$6 A Out GND CIDNMOS L=5U W=15U AS=187.5P AD=56.25P PS=55U PD=22.5U
M$4 GND B \$6 GND CIDNMOS L=5U W=15U AS=56.25P AD=187.5P PS=22.5U PD=55U
.ENDS NAND2X1
