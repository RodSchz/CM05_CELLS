* Extracted by KLayout (CIDESI_CM05, LNunT, CIDESI)

.SUBCKT Buffer VDD A Out GND
M$1 VDD A \$3 VDD CIDPMOS L=5U W=25U AS=312.5P AD=187.5P PS=75U PD=40U
M$2 Out \$3 VDD VDD CIDPMOS L=5U W=25U AS=187.5P AD=312.5P PS=40U PD=75U
M$3 GND A \$3 GND CIDNMOS L=5U W=10U AS=125P AD=75P PS=45U PD=25U
M$4 Out \$3 GND GND CIDNMOS L=5U W=10U AS=75P AD=125P PS=25U PD=45U
C$5 A VDD 2.87761104052e-15 ; C_PAR_M1M2
C$6 Out VDD 2.87761104052e-15 ; C_PAR_M1M2
C$7 Out GND 2.87761104052e-15 ; C_PAR_M1M2
C$8 A GND 2.87761104052e-15 ; C_PAR_M1M2
C$9 GND GND 3.0114534145e-15 ; C_M1_SUB
C$10 GND GND 3.0114534145e-15 ; C_M1_SUB
C$11 GND GND 1.8068720487e-14 ; C_M1_SUB
C$12 Out GND 4.01527121934e-15 ; C_M1_SUB
C$13 \$3 GND 4.01527121934e-15 ; C_M1_SUB
C$14 A GND 5.01908902417e-15 ; C_M1_SUB
C$15 \$3 GND 3.0114534145e-15 ; C_M1_SUB
C$16 \$3 GND 1.2045813658e-14 ; C_M1_SUB
C$17 \$3 VDD 1.2045813658e-14 ; C_M1_NW
C$18 Out VDD 1.05400869508e-14 ; C_M1_NW
C$19 VDD VDD 1.2045813658e-14 ; C_M1_NW
C$20 VDD VDD 3.0114534145e-15 ; C_M1_NW
C$21 VDD VDD 3.0114534145e-15 ; C_M1_NW
C$22 A GND 9.92279669147e-16 ; C_M2_SUB
C$23 Out GND 9.92279669147e-16 ; C_M2_SUB
C$24 A GND 1.19073560298e-14 ; C_M2_SUB
C$25 A GND 2.48069917287e-15 ; C_M2_SUB
C$26 Out GND 1.76956540998e-14 ; C_M2_SUB
C$27 A VDD 1.68687543755e-14 ; C_M2_NW
C$28 Out VDD 1.2734255754e-14 ; C_M2_NW
C$29 A VDD 9.92279669147e-16 ; C_M2_NW
C$30 Out VDD 9.92279669147e-16 ; C_M2_NW
C$31 A GND 1.30800501842e-15 ; C_PO_SUB
C$32 \$3 GND 1.30800501842e-15 ; C_PO_SUB
C$33 A GND 2.61601003684e-14 ; C_PO_SUB
C$34 \$3 GND 1.5696060221e-14 ; C_PO_SUB
C$35 A VDD 7.84803011052e-15 ; C_PO_NW
C$36 \$3 VDD 7.84803011052e-15 ; C_PO_NW
C$37 A VDD 1.30800501842e-15 ; C_PO_NW
C$38 \$3 VDD 1.30800501842e-15 ; C_PO_NW
.ENDS Buffer
