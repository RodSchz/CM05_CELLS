* Extracted by KLayout (CIDESI_CM05, LNunT, CIDESI)

.SUBCKT Buffer VDD A Out GND
M$1 VDD A \$3 VDD CIDPMOS L=5U W=25U AS=312.5P AD=187.5P PS=75U PD=40U
M$2 Out \$3 VDD VDD CIDPMOS L=5U W=25U AS=187.5P AD=312.5P PS=40U PD=75U
M$3 GND A \$3 GND CIDNMOS L=5U W=10U AS=125P AD=75P PS=45U PD=25U
M$4 Out \$3 GND GND CIDNMOS L=5U W=10U AS=75P AD=125P PS=25U PD=45U
.ENDS Buffer
