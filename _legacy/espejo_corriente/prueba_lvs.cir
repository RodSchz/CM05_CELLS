* C:\Users\Lenovo\OneDrive\Documentos\Espejo_corriente\prueba_lvs.asc
* Generated by LTspice 26.0.1 for Windows.
*XX1 NC_01 NC_02 NC_03 cmirror

* block symbol definitions
.subckt cmirror COM P1 P2
M1 P1 P1 COM COM CIDNMOS l=10u w=100u
M2 P2 P1 COM COM CIDNMOS l=10u w=100u
.ends cmirror

.model NMOS NMOS
.model PMOS PMOS
.lib C:\Users\Lenovo\AppData\Local\LTspice\lib\cmp\standard.mos
.backanno
.end
