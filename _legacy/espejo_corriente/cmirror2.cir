* Extracted by KLayout (CIDESI_CM05, LNunT, CIDESI)

.SUBCKT cmirror2 P1 P2 COM
M$1 COM P1 P1 COM CIDNMOS L=10U W=100U AS=2000P AD=1250P PS=240U PD=125U
M$2 P2 P1 COM COM CIDNMOS L=10U W=100U AS=1250P AD=2000P PS=125U PD=240U
.ENDS cmirror2
