* ======================================================================
* Archivo de Prueba DEFINITIVO v4
* CORREGIDO: Se eliminó la definición del vector 'let' y se usa
* una lista directa en el bucle 'foreach'.
* ======================================================================

* --- 1. Definición del Modelo del Capacitor ---
************************************************************************
.SUBCKT MIM_CAP_SiO2 1 2 L=1u W=1u
.PARAM C_per_area = 8.632650e-05
.PARAM R_sheet_T  = 7.000000e-02
.PARAM R_sheet_B  = 1.400000e-01
.PARAM T_nom = 25
.PARAM TC1   = 40e-6
.PARAM TC2   = 0
.PARAM C_base = 'C_per_area * L * W'
.FUNC C_temp(V, temperatura) {C_base * (1 + TC1*(temperatura - T_nom) + TC2*pow(temperatura - T_nom, 2))}
R_top 1 3 'R_sheet_T * W/L'
C1    3 4 'C_temp(V(3,4), TEMPER)'
R_bot 4 2 'R_sheet_B * W/L'
.ENDS MIM_CAP_SiO2

* --- 2. Circuito de Prueba ---
Vac in 0 AC 1
Xcap1 in 0 MIM_CAP_SiO2 L=50u W=50u

* --- 3. Comando de Simulación ---
.AC DEC 20 1Meg 50G

* --- 4. Control, Barrido y Graficado ---
.CONTROL
  * Inicia un bucle que recorre directamente la lista de valores
  foreach t 0 25 100
    set temp = $t
    run
  end

  * Después de que todas las simulaciones han corrido, grafica los resultados
  set xlog
  plot real(v(in)/I(Vac)) title 'Resistencia Serie (ESR)'
  plot mag(v(in)/I(Vac)) title 'Magnitud de Impedancia'
.ENDC

.END
